// A linear resistor: the Verilog-A load tests/conformance/vera/osdi/mixed.sp
// puts on each output of the Verilog module mixed.v, both `vera --emit-osdi`
// libraries in one ngspice deck.
`include "disciplines.vams"

module vload(p, n);
    inout p, n;
    electrical p, n;
    parameter real r = 1k from (0:inf);
    analog I(p, n) <+ V(p, n) / r;
endmodule
