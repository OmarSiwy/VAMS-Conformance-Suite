// A linear resistor with a parallel capacitor and its thermal noise: the
// `vera --emit-osdi` fixture tests/conformance/vera/osdi/resistor.sp loads
// in ngspice. Every value it checks is derived by hand in that deck.
`include "disciplines.vams"

module vres(p, n);
    inout p, n;
    electrical p, n;
    parameter real r = 1k from (0:inf);
    parameter real c = 0 from [0:inf);
    analog begin
        I(p, n) <+ V(p, n) / r;
        I(p, n) <+ ddt(c * V(p, n));
        I(p, n) <+ white_noise(4 * 1.380649e-23 * $temperature / r, "thermal");
    end
endmodule
