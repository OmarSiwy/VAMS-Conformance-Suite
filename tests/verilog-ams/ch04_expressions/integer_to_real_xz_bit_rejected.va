// §4.2.1.2: "Implicit conversion shall take place when an expression is
// assigned to a real. Individual bits that are x or z in the net or the
// variable shall be an error (see 7.3.2)." §7.3.2 says it of every analog
// context operand: "Accessing digital net and digital binary constant operands
// are supported within analog context expressions. It is an error if these
// operands return x or z bit values when solved."
//
// `r = 4'b10x1;` assigns to a real a 4-bit binary constant whose bit 1 is x.
// The integer-to-real conversion the clause requires has no value to produce
// for that bit, and the clause names the outcome: an error. With `4'b1011`
// (bit 1 a 1) the same assignment converts to 11.0 and the file compiles
// (checked by hand when this fixture was written).
//
// VerA's code for this is E0130, the same one ch07_mixed_signal/
// x_literal_unsupported.va and xz_contribution_rejected.va pin for §7.3.2's
// assignment and contribution forms; this row is the §4.2.1.2 conversion.
//
//! lrm 4.2.1.2
//! lrm 4.2.1.2:2
//! reject-only E0130
//! neighbour ../../verilog-a/ch04_expressions/implicit_conversion_to_real.va
`include "disciplines.vams"
module ch04_integer_to_real_xz_bit(p, n);
    inout p, n;
    electrical p, n;
    real r;

    analog begin
        r = 4'b10x1;
        I(p, n) <+ r * V(p, n) * 1.0e-3;
    end
endmodule
