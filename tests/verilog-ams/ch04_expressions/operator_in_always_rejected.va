// LRM 4.5.15, verbatim: analog operators "can not be used inside an initial or
// always block".
//
// operator_in_initial.va is the `initial` half. This is `always`, and it is
// the harder of the two: an `always` block DOES run repeatedly, so unlike
// `initial` it looks superficially like a place a stateful operator could live.
// It cannot — an `always` block is scheduled by the digital kernel on its own
// events, not once per accepted analog timepoint, so `ddt` there would be asked
// to differentiate with respect to a time that did not advance.
//
//! lrm 4.5.15
//! reject-only E0422
`include "disciplines.vams"
module ch04_operator_in_always_rejected(p, n);
    inout p, n;
    electrical p, n;
    real x;

    always x = ddt(V(p, n));

    analog I(p, n) <+ x;
endmodule
