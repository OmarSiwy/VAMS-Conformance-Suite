// §4.2.1: "The operators shown in Table 4-2 are legal when applied to real
// operands. All other operators are considered illegal when used with real
// operands." Table 4-2 does not list `===` or `!==`, and both operands here are
// real, so full Verilog-AMS refuses this module. E0369 is that refusal.
//
// NOT C.5. Annex C.5 ("The case equality operators (===, !==) are not supported
// in Verilog-A") is a rule of the Verilog-A SUBSET, and VerA targets full AMS:
// on integer operands the operators are accepted, as §7.3.2 requires
// (annex_c_analog_subset/case_equality_accepted.va, which used to pin E0323
// on C.5 and was inverted). This file used to cite C.5 as the categorical rule;
// the real-operand rule is the one left standing.
//
// NOT 4.2.6. Read whole, 4.2.6 says the opposite: "These operators have limited
// support in the analog block (see 7.3.2)", and 7.3.2 then PRINTS
// `if (dnet === 1'b1)` inside an `analog begin` as a legal a2d example. Citing
// 4.2.6 here would have demanded a diagnostic the clause forbids.
//
//! lrm 4.2.1
//! lrm 4.2.1:1
//! reject-only E0369
//! neighbour ../annex_c_analog_subset/case_equality_accepted.va
`include "disciplines.vams"
module ch04_case_equality(p, n);
    inout p, n;
    electrical p, n;
    integer value;

    analog begin
        value = (V(p, n) === 0.0) + (V(p, n) !== 1.0);
        I(p, n) <+ value;
    end
endmodule
