// LRM 4.7.3: an analog user-defined function "shall only be called within the
// analog context, either from an analog block or from within another analog
// user-defined function".
//
// The restriction follows from what an analog function IS. 4.7.1 forbids it
// access functions, filters and contribution statements precisely so that it is
// a pure value computation on the analog solver's timeline; calling it from an
// `initial` block, which runs once before the solve, asks for a value at a
// point where that timeline does not exist yet.
//
// user_function.va is the legal call from an analog block, and
// function_indirect_recursion.va is the other legal context — a call from
// inside another analog function — being used illegally.
//
// The expected diagnostic names the CONSTRUCT, `scale`, and not an LRM section
// number: no compiler but VerA prints section numbers in messages, and the
// suite has to be readable by any of them.
//
//! lrm 4.7.3
//! lrm 4.7.3:2
//! reject-only scale
//! reject analog
//! reject E0430
//! neighbour ../../verilog-a/ch04_expressions/user_function.va
`include "disciplines.vams"
module ch04_function_called_outside_analog_rejected(p, n);
    inout p, n;
    electrical p, n;
    real r;

    analog function real scale;
        input x;
        real x;
        scale = x * 2.0;
    endfunction

    initial r = scale(1.0);

    analog I(p, n) <+ r;
endmodule
