// §4.2.6: "The case equality operators share the same level of precedence as
// the logical equality operators. These operators have limited support in the
// analog block (see 7.3.2)." The limit that applies to every context is
// §4.2.1's: "The operators shown in Table 4-2 are legal when applied to real
// operands. All other operators are considered illegal when used with real
// operands." Table 4-2's equality row is `== !=` — `===` and `!==` are not in
// it.
//
// `r1 === r2` compares two reals with a case equality operator. The same line
// with `==` is Table 4-2's legal form and compiles (checked by hand when this
// fixture was written); with integer operands `===` is legal too, which
// annex_a_syntax/case_equality_in_analog.va runs.
//
//! lrm 4.2.6
//! lrm 4.2.1
//! lrm 4.2.1:1
//! reject-only E0369
//! neighbour ../annex_a_syntax/case_equality_in_analog.va
`include "disciplines.vams"
module ch04_case_equality_real_operand(a, b);
    inout a, b;
    electrical a, b;
    real r1, r2;
    integer same;

    analog begin
        r1 = V(a);
        r2 = V(b);
        same = (r1 === r2);
        I(a, b) <+ same * V(a, b) * 1.0e-3;
    end
endmodule
