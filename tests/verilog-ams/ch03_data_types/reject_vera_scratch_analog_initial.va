// VerA's `vera_scratch` attribute (§2.9) on a variable an `analog initial`
// block assigns for the analog block to read.
//
// §5.2.1: an `analog initial` block runs once, before the first evaluation of
// the analog block, so what it assigns reaches the later evaluations only by
// being held. A scratch variable would read 0 on every evaluation of the
// analog block, so the attribute is refused with E0536. The legal neighbour is
// a scratch variable every evaluation assigns before reading, as in
// vera_scratch_starts_each_evaluation.va.
//! lrm 2.9
//! lrm 5.2.1
//! reject-only E0536
//! neighbour ../../verilog-a/ch03_data_types/vera_scratch_starts_each_evaluation.va
`include "disciplines.vams"
module reject_vera_scratch_analog_initial(p, n);
  inout p, n; electrical p, n;
  (* vera_scratch *) real g;
  analog initial g = 1m;
  analog I(p, n) <+ g * V(p, n);
endmodule
