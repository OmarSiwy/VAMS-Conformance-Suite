// §3.6.3.2: "Nets with continuous disciplines are allowed to have initializers
// on their net discipline declarations; however, nets of non-continuous
// disciplines are not."
//
// The reason is the rest of the clause: the initializer "will be used as a
// nodeset value for the POTENTIAL of the net". §3.6.2.2 makes a `domain
// discrete` discipline natureless — it is the LRM's own example `discipline
// ddiscrete; domain discrete; enddiscipline` — so `flag` has no potential, and
// a starting guess at a quantity that does not exist cannot be given one.
//
// ground_non_continuous.va is the same sentence about `ground` (E0344): that
// clause also needs a continuous discipline, also because the thing it declares
// — the zero of a potential — is undefined without a nature. The two rules are
// deliberately separate codes, since a net can violate either alone.
//
// As in 62, annex C.4 also reaches this source in a `.va` file ("the domain
// binding type discrete ... is an error in Verilog-A"), and a phase label could
// not tell the two apart. The pinned CODE can: E0366 is reported at the
// declaration that carries the `=`, which is the part annex C.4 says nothing
// about.
//
//! lrm 3.6.3.2
//! lrm 3.6.3.2:1
//! reject-only E0366
`include "disciplines.vams"
discipline ch3_nodeset_discrete;
    domain discrete;
enddiscipline

module ch03_nodeset_non_continuous(p, n);
    inout p, n;
    electrical p, n;
    ch3_nodeset_discrete flag = 1.0;

    analog begin
        I(p, n) <+ V(p, n);
    end
endmodule
