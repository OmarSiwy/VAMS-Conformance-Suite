// §3.7: "wreal nets can only be connected to compatible interconnect and other
// wreal or real expressions. ... Compatible interconnect are nets of type
// wire, tri, and wreal where the IEEE Std 1364 Verilog net resolution is
// extended for wreal. When the two nets connected by a port are of net type
// wreal and wire/tri, the resulting single net will be assigned as wreal.
// Connection to other net types will result in an error."
//
// The compatible list is closed: wire, tri, wreal. `n` in the parent is a
// `wand`, whose identity is its wired-AND resolution function, and it is
// connected to the child's wreal output port. The merge rule "the resulting
// single net will be assigned as wreal" would delete that function, and the
// last sentence makes the connection an error instead.
//
// This is the analog-route twin of digital/reject_wreal_connected_to_wand.v
// (the digital runner's transcript, which --coverage does not read). With
// `wire n;` instead the same design is the wire/tri case §3.7 promotes to
// wreal, covered by wreal_wire_port_merge.va. That positive twin currently
// fails — the merged port reads the 2.5 driver as integer 2 — so this row
// stops at E2 (exact cite + passing reject) until the compiler is fixed.
//
//! lrm 3.7
//! lrm 3.7:1002
//! reject-only E0919
//! neighbour wreal_wire_port_merge.va
`include "disciplines.vams"
module ch3_wreal_to_wand_child(o);
    output o;
    wreal o;
    assign o = 2.5;
endmodule

module ch3_wreal_connected_to_wand(p, q);
    inout p, q;
    electrical p, q;
    wand n;
    ch3_wreal_to_wand_child u(.o(n));

    analog begin
        I(p, q) <+ V(p, q) * 1.0e-3;
    end
endmodule
