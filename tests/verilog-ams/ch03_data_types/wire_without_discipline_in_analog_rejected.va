// §3.6.2.4: "It is possible for a module to have nets where there are no
// discipline declarations. ... If it is referenced in behavioral code, then it
// must have a net type. In these cases, the net shall be treated as having no
// discipline. If the net is referenced in behavioral code, then it shall be
// treated as having no discipline with a domain binding of discrete".
//
// `w` is declared `wire` and nothing else, and the analog block reads V(w).
// By §3.6.2.4 it is then a DISCRETE net with no discipline, and §3.6.3 states
// the consequence: "Nets declared with a natureless discipline or declared
// without a discipline do not have declared natures, so such nets can not be
// used in analog behavioral descriptions (because the access functions are not
// known)." There is no `V` for w to be read through.
//
// With `electrical w;` added the same module compiles (checked by hand when
// this fixture was written): the defect is the missing discipline alone.
// implicit_nets.va is the legal side — undeclared nets that appear only in
// port connections, which §3.6.2.4 permits.
//
//! lrm 3.6.2.4
//! lrm 3.6.2.4:2
//! lrm 3.6.2.4:3
//! lrm 3.6.2.4:4
//! lrm 3.6.3
//! lrm 3.6.2
//! lrm 3.6.2:3
//! reject-only E0337
//! neighbour ../../verilog-a/ch03_data_types/implicit_nets.va
`include "disciplines.vams"
module ch3_wire_without_discipline_in_analog(p, n);
    inout p, n;
    electrical p, n;
    wire w;

    analog begin
        I(p, n) <+ V(w) * 1.0e-3;
    end
endmodule
