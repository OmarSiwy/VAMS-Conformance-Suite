// §3.6.2.2: "The domain attribute is optional. The default value for domain is
// continuous for disciplines which specify nature bindings. It is an error for
// a discipline to have a domain binding of discrete if it has nature bindings."
//
// `ch3_discrete_natured` writes `domain discrete` and then binds a potential
// nature, which is exactly the pair that sentence forbids. Both halves are
// individually well-formed — the LRM's own §3.6.2.2 example `discipline
// ddiscrete; domain discrete; enddiscipline` is legal with no natures, and the
// same nature bound under `domain continuous` is legal too — so the error is in
// the combination and nothing else.
//
// annex_c_analog_subset/07_discrete_discipline_current_behavior.va declares a
// discrete discipline with NO nature bindings and therefore never reaches this
// rule. In a `.va` file annex C.4 also bears on `domain discrete`, which the
// phase label this file used to pin could not tell apart; E0339 ("`domain
// discrete` on a discipline that binds a nature") is the §3.6.2.2 combination
// and nothing else, so it is what is pinned now.
//
//! lrm 3.6.2.2
//! lrm 3.6.2.2:2
//! reject-only E0339
//! neighbour ../../verilog-a/ch03_data_types/discipline_declarations.va
nature ch3_discrete_n; units="V"; access=DiscreteV; abstol=1u; endnature
discipline ch3_discrete_natured;
    domain discrete;
    potential ch3_discrete_n;
enddiscipline
module ch3_discrete_domain_with_natures; endmodule
