// §3.6.4: "Each ground declaration is associated with an already declared net of
// continuous discipline. The node associated with the net will be the global
// reference node in the circuit. The net must be assigned a continuous
// discipline to be declared ground."
//
// `ref_net` has discipline `ch3_ground_discrete`, whose `domain discrete`
// binding is legal on its own — it is the LRM's own §3.6.2.2 example
// `discipline ddiscrete; domain discrete; enddiscipline` — and which
// §3.6.2.2 also makes natureless, so the net has no potential at all and there
// is nothing for a global reference node to be the reference OF.
//
// ground_declaration.va grounds an electrical net, i.e. the legal case.
//
// Pin E0344 at the ground declaration, independently of the Annex C.4
// analog-profile restriction on discrete domains. A generic phase failure
// cannot distinguish those rules. Domainless disciplines also exist; do not
// infer that every discipline without an explicit discrete domain is continuous.
//
//! lrm 3.6.4
//! lrm 3.6.4:1
//! reject-only E0344
//! neighbour ../../verilog-a/ch03_data_types/ground_declaration.va
`include "disciplines.vams"
discipline ch3_ground_discrete;
    domain discrete;
enddiscipline

module ch3_ground_non_continuous(p);
    inout p;
    electrical p;
    ch3_ground_discrete ref_net;
    ground ref_net;

    analog begin
        V(p) <+ 0.0;
    end
endmodule
