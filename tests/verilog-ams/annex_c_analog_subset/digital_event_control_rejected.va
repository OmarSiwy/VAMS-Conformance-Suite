// Annex C.7, bullet 1: "No digital behavior or events are supported in
// Verilog-A."
//
// The cite is 5.10.5, not 5.10. §5.10 is where `posedge`/`negedge` are GRANTED:
// Syntax 5-13, repeated verbatim in A.6.5, reads
//
//   analog_event_expression ::= expression | posedge expression
//                             | negedge expression | ...
//
// so arguing from §5.10 would argue against this fixture. What C.7 removes is
// §5.10.5, "Digital events in analog behavior": "To model mixed signal
// functionality, analog behavior can be made sensitive to digital events,
// including posedge events, negedge events, state change events, and named
// events." That sensitivity is the mixed-signal feature, and it is the one the
// subset drops. The analog events of §5.10.2/5.10.3 (`initial_step`, `cross`,
// `timer`, ...) stay, and analog_event.va pins them on the positive side;
// a named event triggered and detected within the analog block is the §5.10.4
// case, which stays too — named_event_in_subset.va.
//
// Both edges appear, and both are pinned, because the parser recovers and
// reports each one: a fixture naming a single edge would leave the other
// unproven.
//
// This fixture used to pin E0209 ("expected an expression", .lrm A.8.3), a
// parser-recovery artifact naming no C.7 rule — VerA had no subset gate here,
// it simply did not parse `posedge` in an event expression. The note left here
// said the cite must move to whatever code refuses the edges once VerA learned
// to parse them. VerA has now learned: §5.10.1 edges parse for the digital
// domain, so lowering is reached and refuses them.
//
// The code is E0704 ("posedge/negedge is digital-only", .lrm 5.10.1), not the
// E0201 that note guessed at. What bites is the domain rule, not subset
// membership: §5.10.5 sensitivity is precisely what C.7 drops, and E0704 is
// the code that states it. E0201 would have said "not in the supported subset"
// without naming which rule, which is the weaker diagnostic.
//
//! lrm C.7
//! lrm 5.10.5
//! reject-only E0704
//! reject posedge
//! reject negedge
//! neighbour ../../verilog-a/annex_c_analog_subset/analog_event.va
//! neighbour named_event_in_subset.va
`include "disciplines.vams"
module annex_c_digital_event_control_rejected(p);
    inout p;
    electrical p;
    integer state;

    analog begin
        @(posedge V(p)) state = 1;
        @(negedge V(p)) state = 2;
        I(p) <+ V(p);
    end
endmodule
