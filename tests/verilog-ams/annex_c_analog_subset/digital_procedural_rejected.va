// Annex C.7, bullet 1: "No digital behavior or events are supported in
// Verilog-A." 13 and 14 cover the two digital procedural BLOCKS; this covers
// two digital procedural STATEMENTS, both meaningless in an analog block
// because both need a digital scheduler:
//
//   A.6.3  par_block ::= fork ... join      concurrent processes; the analog
//                                           block is a single ordered process.
//   A.6.5  wait_statement ::= wait ( expression ) statement_or_null
//                                           blocks until a variable changes,
//                                           which is a digital event.
//
// Both are in one file because each is parsed in full and refused by its own
// clause, and each is pinned as its own substring — dropping one arm FAILs
// instead of passing on its neighbour's diagnostic: E0255 names A.6.5's
// wait_statement, E0249 A.6.3's par_block ("a fork-join block"). Until
// 2026-10 both were the parser's generic E0209, a recovery artifact that named
// no rule. `disable`, whose diagnostic comes from a later stage that does not
// run at all once a parse error exists, is 27.
//
//! lrm C.7
//! lrm A.6.3
//! lrm A.6.5
//! lrm A.6.4
//! lrm A.6.4:1000
//! reject-only E0255
//! reject E0249
//! reject fork
//! reject join
//! reject wait
`include "disciplines.vams"
module annex_c_digital_procedural_rejected(p);
    inout p;
    electrical p;
    integer state;

    analog begin
        wait (state) state = 0;
        fork
            state = 1;
        join
        I(p) <+ V(p);
    end
endmodule
