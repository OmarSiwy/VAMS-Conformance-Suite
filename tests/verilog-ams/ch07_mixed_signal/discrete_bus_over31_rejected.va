// §7.3.1 Table 7-1, the `bit` row, last sentence: "Access of discrete bit
// groupings with greater than 31 bits is illegal." This is the only prohibition
// in that row — the mapping rules above it make 8 and 31 bits legal (see
// discrete_bus_narrow.va and discrete_bus_31.va, which must RUN and now do) — so
// a diagnostic here has to be about the WIDTH and not about vector syntax, or the
// boundary is untested in both directions.
//
// 32 bits is one over the limit, and it is the width that makes the rule
// necessary: bit 31 of a 32-bit grouping has nowhere to go, because Table 7-1
// also requires the integer's sign bit to be zero.
//
// VerA reports the WIDTH, at E0222, and now reports NOTHING ELSE: the `reg` and
// the constant `initial` block are accepted (they are legal Verilog-AMS —
// A.2.1.3, A.6.2), so the width diagnostic is the only thing separating this file
// from its two legal-width siblings. The substring pin states the RULE, because
// that claim travels: no other compiler prints E0222, and what has to be true of
// any of them is that the 32-bit grouping was refused for its width. E0222 is
// pinned beside it for VerA, so that a different diagnostic which happens to
// use the same words cannot satisfy the file.
//
//! lrm 7.3.1
//! lrm 7.3.1:1
//! reject-only bit grouping wider than 31 bits
//! reject E0222
//! neighbour discrete_bus_31.va
//! neighbour discrete_bus_narrow.va
`include "disciplines.vams"
module ch7_discrete_bus_over31(p);
  inout p; electrical p;
  reg [31:0] r;
  initial r = 32'h00000001;
  analog I(p) <+ r;
endmodule
