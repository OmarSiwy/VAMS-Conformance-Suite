// §7.3.1 Table 7-1, the `bit` row: "Access of discrete bit groupings with
// greater than 31 bits is illegal." r[31:0] is a 32-bit grouping of a 40-bit
// `reg`: the access, not the declaration, is what the row forbids.
//
// Legal neighbour: discrete_bus_part_select_31.va, the same 40-bit `reg` read
// through 31-bit selects.
//
//! lrm 7.3.1
//! lrm 7.3.1:1
//! reject-only E0222
//! reject this analog access reads 32 bits
//! neighbour discrete_bus_part_select_31.va
`include "disciplines.vams"
module ch7_discrete_bus_part_select_32(p);
  inout p; electrical p;
  reg [39:0] r;
  initial r = 40'h1;
  analog I(p) <+ r[31:0];
endmodule
