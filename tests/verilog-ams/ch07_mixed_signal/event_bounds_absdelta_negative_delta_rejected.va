// §5.10.3.4: "delta shall be non-negative". Here -0.25 is a constant
// negative delta; the event is in its required digital context and every
// other argument is legal. event_bounds_mixed_legal.va runs the zero boundary
// and a positive delta through the emitted mixed-signal host.
//! lrm 5.10.3.4
//! lrm 5.10.3.4:2
//! reject-only E0517
//! neighbour event_bounds_mixed_legal.va
`include "disciplines.vams"
module event_bounds_absdelta_negative_delta(p);
  inout p; electrical p;
  real sampled;
  always @(absdelta(V(p), -0.25, 1p, 1m, 1)) sampled = V(p);
  analog I(p) <+ 0.0;
endmodule
