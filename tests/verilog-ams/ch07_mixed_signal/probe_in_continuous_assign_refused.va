// VAMS §7.3.6.3 lets a digital expression read a continuous net's potential
// ("the analog value calculated for the time corresponding to a real promotion
// of the digital time"), and §6.1 (IEEE 1364-2005) re-evaluates a continuous
// assignment "whenever an operand changes". An analog probe's operand is the
// analog solution, which VerA's digital engine holds in no variable, so an
// assignment reading one could never be woken: it would read V(a) once and
// keep that value however the solution moved. VerA refuses it by name
// (E1100, the digital engine's "not implemented") when the testbench
// elaborates the digital half, rather than freeze it; before 2026-10-08 the
// sensitivity walk reached `unreachable` here and the run crashed.
//
// This is an engine limit, not a rule of the LRM, so it cites no clause.
// probe_in_procedural_read.va is the legal neighbour: the same probe read by
// a procedural assignment, which runs when its process does.
//
//! reject-run E1100
//! neighbour probe_in_procedural_read.va
//! analysis tran
//! time 0, 2n
//! solve
`include "disciplines.vams"
`timescale 1ns/1ns
module probe_in_continuous_assign_refused(a);
  inout a; electrical a;
  wire hi;
  assign hi = V(a) > 0.5;
  analog V(a) <+ 1.0;
endmodule
