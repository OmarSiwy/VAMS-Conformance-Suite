// §5.5.3 forbids the access, ddt_nature and idt_nature attributes in a
// nature_attribute_reference. Keeping a child's local discipline across a
// port connection must preserve that refusal. Here the legal neighbour is
// mixed_signal_smallest_abstol.va: its bound child reads p.potential.abstol; this child instead
// reads the forbidden p.potential.access and must receive E0359.
//! lrm 5.5.3
//! lrm 5.5.3:1
//! reject-only E0359
//! neighbour mixed_signal_smallest_abstol.va
`include "disciplines.vams"
nature local_attribute_voltage : Voltage;
  abstol = 1n;
endnature
discipline local_attribute_disc;
  potential local_attribute_voltage;
  flow Current;
enddiscipline
module local_attribute_child(p);
  inout p; local_attribute_disc p;
  analog I(p) <+ p.potential.access;
endmodule
module node_abstol_local_attribute_rejected(p);
  inout p; electrical p;
  local_attribute_child child(p);
endmodule
