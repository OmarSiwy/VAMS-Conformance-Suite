// A continuous assignment into a net of a CONTINUOUS discipline: the refusal
// that stays when ddiscrete_net_continuously_assigned.va is accepted.
//
// §7.2: "only digital blocks and primitives can drive a discrete net (drivers),
// and only analog blocks can contribute to an analog net (contributions)."
// §7.3: "Write operations of nets and variables are only allowed from the
// context of their domain." §7.2.2 puts "a continuous_assign statement" in the
// discrete context, and `electrical` binds natures, so §3.6.2.2 makes its
// domain continuous. `e` is a net, so this is not E0438 (a variable target);
// it is the domain rule, E0435.
//
//! lrm 7.2
//! lrm 7.3
//! lrm 3.6.2.2
//! lrm 7.2.3
//! lrm 7.2.3:1000
//! lrm 7.3:1000
//! reject-only E0435
//! neighbour ddiscrete_net_continuously_assigned.va
`include "disciplines.vams"
module ch7_continuous_net_continuously_assigned(p);
  inout p;
  electrical p;
  electrical e;

  assign e = 1'b1;

  analog
    I(p) <+ V(p);
endmodule
