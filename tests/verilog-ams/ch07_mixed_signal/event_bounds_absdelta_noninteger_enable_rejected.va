// §5.10.3.4: "The enable argument ... shall evaluate to an integer."
// 0.5 is not integral, and the clause specifies no rounding for this slot.
// All other arguments and the digital placement are legal. The neighbor
// event_bounds_mixed_legal.va runs both the integer 1 and the integral real
// 1.0, so this rule cannot become a blanket refusal of real expressions.
//! lrm 5.10.3.4
//! lrm 5.10.3.4:4
//! reject-only E0517
//! neighbour event_bounds_mixed_legal.va
`include "disciplines.vams"
module event_bounds_absdelta_noninteger_enable(p);
  inout p; electrical p;
  real sampled;
  always @(absdelta(V(p), 0.25, 1p, 1m, 0.5)) sampled = V(p);
  analog I(p) <+ 0.0;
endmodule
