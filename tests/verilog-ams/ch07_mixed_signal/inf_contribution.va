// §7.3.2.1 special floating point values: "Floating point arithmetic can
// produce special values representing plus and minus infinity and Not-a-Number
// (NaN) ... While use of these special numbers in digital expressions is not an
// error, it is illegal to assign these values to a branch through contribution
// in the analog context."
//
// The contribution below is that illegal form and nothing else: +inf reaches a
// branch through `<+`. VerA accepts it — it emits only W0650 ("unit is not
// provably finite") and stamps the value — so the rule is unmet, not unstated,
// and the fixture is marked accordingly rather than softened.
//
// The value is formed by the arithmetic the clause itself names — 1.0/0.0 is
// the IEEE 754 division of a finite positive by zero, whose result is +inf —
// and NOT with the `inf` keyword. `inf` is a reserved word with exactly one
// grammar position: annex A gives
// `value_range_expression ::= constant_expression | -inf | inf`, and it is
// absent from the A.8.4 `primary` list this very chapter reprints as Syntax
// 7-1. Writing `I(p) <+ inf` would put a syntax error in the file in place of
// the §7.3.2.1 violation, and a conforming compiler would then diagnose the
// grammar and never reach the rule this fixture demands. (VerA does accept
// `inf` as a primary — lib/frontend/parser.zig maps the keyword to `.pos_inf`
// — which is precisely why the fixture must not lean on it.) Same construction
// as the two siblings: neg_inf_contribution_rejected.va uses -1.0/0.0 and
// nan_contribution_rejected.va uses 0.0/0.0.
//
// There is deliberately no run-side assertion. The LRM fixes no value for a
// branch an infinity reached, and a comparison guard would assert a property of
// IEEE arithmetic rather than the contribution rule.
//
//! lrm 7.3.2.1
//! lrm 7.3.2.1:1
//! reject-only contribution of an infinite value
//! reject E0424
//! neighbour special_float_values_in_digital_expressions.va
`include "disciplines.vams"
module ch7_infinity_contribution(p);
  inout p; electrical p;
  real bad;
  analog begin
    bad = 1.0/0.0;
    I(p) <+ bad + 0.0*V(p);
  end
endmodule
