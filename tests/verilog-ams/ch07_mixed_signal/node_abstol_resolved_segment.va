// §7.2.4 gives a shared node the smallest potential abstol of every
// continuous segment. §7.4.1 resolves each undeclared segment from its lower
// connections, even below a declared parent (Figure 7-5, Case 2). The
// §7.7.2.1 result discipline need not be one of the listed disciplines.
//
// Here p is declared 10u in the top and wrapper. Inside mid, the undeclared
// p joins 100n and 10n leaves, and resolveto gives that segment 100p. Thus
// the shared node publishes min(10u, 100n, 10n, 100p) = 100p. Source reads
// keep each segment's own §5.5.3 attribute, including mid's resolved 100p.
// Five source checks plus the host metadata check give six verdicts.
// This minimum has no invalid form; compatible_disciplines_without_resolveto_rejected
// covers §7.2.4's separate requirement for a resolution statement.
//! lrm 7.2.4
//! lrm 7.4.1
//! lrm 7.7.2.1
//! lrm 5.5.3
//! lrm 6.5.8
//! lrm 6.5.8:3
//! lrm 7.2.4:1
//! lrm 7.4.1:1000
//! lrm 7.7.2
//! lrm 7.7.2:1000
//! lrm 7.7.2.1:1003
//! bias V(p) = 0.5
//! abstol p = 1e-10
//! checks 6
// Own base natures below: D.1's guard keeps annex D's out of check.vh's include.
`define DISCIPLINES_VAMS 1
`include "check.vh"
nature seg_voltage;
  units = "V"; access = V; abstol = 10u;
endnature
nature seg_a : seg_voltage; abstol = 100n; endnature
nature seg_b : seg_voltage; abstol = 10n; endnature
nature seg_result : seg_voltage; abstol = 100p; endnature
nature seg_current;
  units = "A"; access = I; abstol = 1p;
endnature
discipline seg_loose; potential seg_voltage; flow seg_current; enddiscipline
discipline seg_da; potential seg_a; flow seg_current; enddiscipline
discipline seg_db; potential seg_b; flow seg_current; enddiscipline
discipline seg_fine; potential seg_result; flow seg_current; enddiscipline
connectrules segment_resolution;
  connect seg_da, seg_db resolveto seg_fine;
endconnectrules
module seg_leaf_a(p);
  inout p; seg_da p;
  analog `CHECKR("leaf a local nature", p.potential.abstol, 1e-7, 1e-12);
endmodule
module seg_leaf_b(p);
  inout p; seg_db p;
  analog `CHECKR("leaf b local nature", p.potential.abstol, 1e-8, 1e-12);
endmodule
module seg_middle(p);
  inout p;
  seg_leaf_a a(p);
  seg_leaf_b b(p);
  analog `CHECKR("middle resolved nature", p.potential.abstol, 1e-10, 1e-12);
endmodule
module seg_wrapper(p);
  inout p; seg_loose p;
  seg_middle mid(p);
endmodule
module node_abstol_resolved_segment(p);
  inout p; seg_loose p;
  seg_wrapper wrapper(p);
  analog begin
    `CHECKR("top declared nature", p.potential.abstol, 1e-5, 1e-12);
    `CHECKX("one shared node", V(p), 0.5);
    I(p) <+ V(p);
  end
endmodule
