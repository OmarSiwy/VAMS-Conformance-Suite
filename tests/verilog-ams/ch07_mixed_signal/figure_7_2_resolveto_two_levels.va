// §7.4.1 Figure 7-2, in the continuous domain.
//
// "If disciplines at the lower connections of ports (where the undeclared net
// is an upper connection) are among the disciplines in discipline_list, the
// result_discipline is the discipline which is assigned to the undeclared net."
//
// The figure's two statements, and the two nets they resolve:
//
//   connect cmos3 cmos4 resolveto cmos3;
//   connect cmos1 cmos2 cmos3 resolveto cmos1;
//
//   "The first connect statement resolves NetB to be assigned the discipline
//   cmos3. NetA has cmos1, cmos2 and the resulting cmos3 from module twoblks at
//   the lower connection ports; based on the second connect statement, it
//   resolves to be assigned the discipline cmos1."
//
// The figure's disciplines are digital, which puts the answer out of reach of a
// flat fixture: nothing reads a discrete net's discipline back. The resolution
// rule itself does not mention a domain, and §7.4.5 says a continuous signal is
// resolved by the same algorithm ("Both algorithms will give the same result as
// there are no discrete disciplines to propagate upwards"), so the figure is
// rebuilt here with four COMPATIBLE continuous disciplines, f72_c1..f72_c4.
// They share one flow nature and their potential natures all derive from
// `f72_v` (§3.6.1.1 derived natures, which §3.11.1 makes compatible), each
// overriding `abstol`:
//
//   discipline  potential   abstol
//   f72_c1      f72_v1      1e-6
//   f72_c2      f72_v2      1e-8
//   f72_c3      f72_v3      1e-7
//   f72_c4      f72_v4      1e-9
//
// §5.5.3 reads a net's potential nature attributes back
// (`net.potential.abstol`), so the discipline a net resolved to is a number.
//
// DERIVATION. `f72_twoblks` leaves NetB undeclared; its lower connections are
// f72_c4 (`b4`) and f72_c3 (`b3`). The set {c3, c4} matches the first statement
// exactly, so NetB is f72_c3. NetB IS twoblks' port, so at the top the lower
// connections of NetA are f72_c2 (`a2`), f72_c3 (the port of `tb`: NetB's
// RESULT, not either of its children) and f72_c1 (`a1`). {c1, c2, c3} matches the
// second statement exactly, so NetA is f72_c1:
//
//   NetA.potential.abstol = 1e-6
//
// What else a compiler could answer, and why none of it is 1e-6:
//   - first arrival wins: `a2` is written first, so NetA would be c2, 1e-8;
//   - the tightest abstol wins (§7.2.4's NODE rule misapplied to the net's
//     discipline): c2, 1e-8 again — which is why c1, the answer, is given the
//     LOOSEST tolerance;
//   - NetB not resolved by the first statement (first arrival there is c4):
//     NetA's set becomes {c1, c2, c4}, which no statement contains exactly or
//     as a subset, so the net is unknown — an error or a first arrival, 1e-8,
//     never c1.
// Only both statements, applied bottom-up, give 1e-6.
// §7.2.4 separately assigns the shared NODE the smallest potential tolerance
// of every continuous segment: min(1e-6, 1e-8, 1e-7, 1e-9) = 1e-9.
// The host-visible abstol assertion distinguishes that node metadata from
// the resolved NetA.potential.abstol attribute checked in the model.
//
//! lrm 7.2.4
//! lrm 7.4.1
//! lrm 7.7.2
//! lrm 5.5.3
//! lrm 7.2.4:1
//! lrm 7.2.4:2
//! lrm 7.4.1:1000
//! lrm 7.4.5
//! lrm 7.4.5:1
//! lrm 7.7.2:1000
//! lrm F.2
//! lrm F.2:2
//! lrm F.2:3
//! lrm F.2:4
//! bias V(NetA) = 0.5
//! abstol NetA = 1e-9
//! print none
// Own base natures below: D.1's guard keeps annex D's out of check.vh's include.
`define DISCIPLINES_VAMS 1
`include "check.vh"
nature f72_i;
  units = "A";
  access = I;
  abstol = 1p;
endnature
nature f72_v;
  units = "V";
  access = V;
  abstol = 1m;
endnature
nature f72_v1 : f72_v;
  abstol = 1u;
endnature
nature f72_v2 : f72_v;
  abstol = 10n;
endnature
nature f72_v3 : f72_v;
  abstol = 100n;
endnature
nature f72_v4 : f72_v;
  abstol = 1n;
endnature
discipline f72_c1; domain continuous; potential f72_v1; flow f72_i; enddiscipline
discipline f72_c2; domain continuous; potential f72_v2; flow f72_i; enddiscipline
discipline f72_c3; domain continuous; potential f72_v3; flow f72_i; enddiscipline
discipline f72_c4; domain continuous; potential f72_v4; flow f72_i; enddiscipline

connectrules f72_rules;
  connect f72_c3, f72_c4 resolveto f72_c3;
  connect f72_c1, f72_c2, f72_c3 resolveto f72_c1;
endconnectrules

module f72_leaf1(p); inout p; f72_c1 p; endmodule
module f72_leaf2(p); inout p; f72_c2 p; endmodule
module f72_leaf3(p); inout p; f72_c3 p; endmodule
module f72_leaf4(p); inout p; f72_c4 p; endmodule

module f72_twoblks(NetB);
  inout NetB;
  f72_leaf4 b4(NetB);
  f72_leaf3 b3(NetB);
  analog `CHECKX("the child segment resolves before its parent", NetB.potential.abstol, 1e-7);
endmodule

module f72_top;
  f72_leaf2 a2(NetA);
  f72_twoblks tb(NetA);
  f72_leaf1 a1(NetA);

  analog begin
    `CHECKX("NetA resolves to f72_c1 through the second resolveto statement", NetA.potential.abstol, 1e-6);
    `CHECKX("the bias reaches NetA through the resolved discipline's access function", V(NetA), 0.5);
    I(NetA) <+ 0.0;
  end
endmodule
