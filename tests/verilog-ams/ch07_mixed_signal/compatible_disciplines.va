// §3.11 discipline compatibility, the rule §7.4.1 resolution is built on. Two
// distinct disciplines are compatible when their natures are — Self Rule
// (Nature): "A nature is compatible with itself" — and ch7_disc_a and
// ch7_disc_b name the very same potential and flow natures.
//
// §3.11 also says why that matters here: "if an access function has two nets as
// arguments, they must be compatible". So V(p, q) across a disc_a net and a
// disc_b net is legal for no reason other than the compatibility above, and it
// is the potential nature's access function (§3.6.1.3 `access = V`) that reads
// the pair.
//
// Biased 2.5 V and 0.5 V, that access function must return the difference, 2.0.
//
//! lrm 3.11
//! lrm 7.4.1
//! lrm 3.11.1
//! lrm 3.11.1:1
//! bias V(p) = 2.5, V(q) = 0.5
// Own base natures below: D.1's guard keeps annex D's out of check.vh's include.
`define DISCIPLINES_VAMS 1
`include "check.vh"
nature ch7_potential;
  units = "V";
  access = V;
  abstol = 1u;
endnature
nature ch7_flow;
  units = "A";
  access = I;
  abstol = 1p;
endnature
discipline ch7_disc_a;
  potential ch7_potential;
  flow ch7_flow;
enddiscipline
discipline ch7_disc_b;
  potential ch7_potential;
  flow ch7_flow;
enddiscipline
module ch7_compatible(p);
  inout p; ch7_disc_a p;
  ch7_disc_b q;
  analog begin
    `CHECKX("the shared potential nature reads a branch spanning two compatible disciplines", V(p, q), 2.0);
    I(p) <+ V(p);
    I(p, q) <+ 0.001 * V(p, q);
  end
endmodule
