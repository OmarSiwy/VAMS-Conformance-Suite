// §3.6.2 a user-declared continuous discipline. Nothing about `electrical` is
// built in: §3.6.1.3 says the nature's `access` attribute is what names the
// access function, so a net of ch7_electrical is read with V() only because
// ch7_voltage says `access = V`, and `domain continuous` is what makes the net
// a conservative analog node in the first place (§7.2.1).
//
// §3.10.1: with only one net given, "the second net defaults to ground", so
// V(p) is p's potential measured against the reference node. Biased at 2.5 V
// that access function must return 2.5.
//
//! lrm 3.6.2
//! lrm 7.2.1
//! bias V(p) = 2.5
// Own base natures below: D.1's guard keeps annex D's out of check.vh's include.
`define DISCIPLINES_VAMS 1
`include "check.vh"
nature ch7_voltage;
  units = "V";
  access = V;
  abstol = 1u;
endnature
nature ch7_current;
  units = "A";
  access = I;
  abstol = 1p;
endnature
discipline ch7_electrical;
  potential ch7_voltage;
  flow ch7_current;
  domain continuous;
enddiscipline
module ch7_custom(p);
  inout p; ch7_electrical p;
  analog begin
    `CHECKX("the user nature's access=V reads p against ground", V(p), 2.5);
    I(p) <+ V(p);
  end
endmodule
