// VerA's `vera_scratch` attribute (§2.9) on a variable a digital process
// assigns.
//
// §7.2.2: "The domain of a variable is that of the context from which its
// value is assigned." `level` below is assigned only by an `initial` block, so
// it is a discrete variable, and IEEE 1364-2005 §4.2.2 says such a variable
// "shall retain value until the next assignment". The attribute resets a
// variable at every ANALOG evaluation; the digital kernel owns this one's
// storage and no analog evaluation touches it, so the attribute would do
// nothing. VerA refuses it with E0537 rather than ignoring it.
//
// The legal neighbour is the same attribute on a variable only the analog
// block assigns: `gain` below carries it and is not refused, so the one
// diagnostic is about `level`. The behaviour of an analog-only scratch
// variable is asserted in ch03_data_types/vera_scratch_starts_each_evaluation.va.
//! lrm 2.9
//! lrm 7.2.2
//! reject-only E0537
//! neighbour ../../verilog-a/ch03_data_types/vera_scratch_starts_each_evaluation.va
`include "disciplines.vams"
module reject_vera_scratch_digital_variable(p);
  inout p; electrical p;
  (* vera_scratch *) real level;
  (* vera_scratch *) real gain;
  initial level = 1.25;
  analog begin
    gain = 2.0;
    I(p) <+ gain * level * V(p);
  end
endmodule
