// §7.3.7 function calls, first sentence: "Digital functions cannot be called
// from within the analog context." The call on the last line is that violation:
// `digital_scale` is declared `function` (not `analog function`), so it is a
// digital function, and its only caller is the analog block.
//
// THE MASK IS GONE, as of 2026-09-21. It used to read: the declaration dies as
// an unsupported module item (E0205) before any caller is analysed, so the
// domain-crossing check never fires. §4.7 admits the declaration ("Each
// function can be an analog user-defined function or a digital function"), so
// refusing it was refusing §4.7 rather than enforcing §7.3.7; the declaration
// is now accepted and the CALL is refused, as E0436.
//
// This file keeps its place beside `m01_90_digital_function_from_analog_
// rejected.va` because the two pin DIFFERENT SPELLINGS of the same rule: this
// one is A.2.6's non-ANSI form with no ports at all (`function real
// digital_scale;`), m01_90 is the ANSI form with a parenthesised `input real
// x`. Both had to start parsing for either to be judged.
//
// The other direction was already unmasked — analog_function_from_digital_
// rejected.va reaches E0430 — and cross_domain_function_unsupported.va, now
// withdrawn to m01_08, was masked by an `always` block, not by the function.
//
//! lrm 7.3.7
//! lrm C.7
//! lrm 7.3.7:1000
//! reject-only E0436
`include "disciplines.vams"
module ch7_digital_function_from_analog(p);
  inout p; electrical p;
  function real digital_scale;
    input real value;
    digital_scale = 2.0 * value;
  endfunction
  analog I(p) <+ digital_scale(V(p));
endmodule
