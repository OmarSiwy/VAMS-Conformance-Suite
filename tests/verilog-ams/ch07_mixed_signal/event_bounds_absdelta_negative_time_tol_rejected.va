// §5.10.3.4: "Both the tolerances (time_tol and expr_tol) ... shall be
// non-negative." Only time_tol is negative here; delta, expr_tol, enable,
// and placement are legal. event_bounds_mixed_legal.va runs non-negative
// tolerances and observes an enabled absdelta monitor.
//! lrm 5.10.3.4
//! lrm 5.10.3.4:3
//! reject-only E0517
//! neighbour event_bounds_mixed_legal.va
`include "disciplines.vams"
module event_bounds_absdelta_negative_time_tol(p);
  inout p; electrical p;
  real sampled;
  always @(absdelta(V(p), 0.25, -1p, 1m, 1)) sampled = V(p);
  analog I(p) <+ 0.0;
endmodule
