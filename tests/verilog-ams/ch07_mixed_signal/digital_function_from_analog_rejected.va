// §7.3.7, both sentences: "Digital functions cannot be called from within the
// analog context. Analog functions cannot be called from within the digital
// context."
//
// The SECOND sentence is already pinned, and pinned well:
// `tests/fixtures/ch07_mixed_signal/analog_function_from_digital_rejected.va`
// gets E0430 reported at the call site inside an `initial` block, with the
// block itself accepted so nothing masks it.
//
// The FIRST sentence had no coverage until 2026-09-21.
// `digital_function_from_analog_unsupported.va` was the right shape but was
// refused at `error[E0205]: unsupported module item` on the `function`
// DECLARATION — VerA had no production for a non-`analog` function at all — so
// no caller was ever analysed and the clause's rule was never reached. Chapter
// 7's tests/fixtures/ch07_mixed_signal/COVERAGE.md at 8b1514d4 said so in as many words: "The other half is still masked".
// The declaration is now accepted and the CALL is refused, as E0436.
//
// WHAT MUST HAPPEN INSTEAD. A Verilog-AMS compiler accepts the declaration —
// §4.7's opening paragraph is the authority, verbatim: "A user-defined function
// can be used to return a value (for an expression). All functions are defined
// within modules. Each function can be an analog user-defined function or a
// digital function (as defined in IEEE Std 1364 Verilog)." So a non-`analog`
// `function real dig_helper(...)` is legal in any module — and the compiler must
// refuse the CALL instead, because the call is the thing
// §7.3.7 forbids. The diagnostic must therefore land on `dig_helper(V(p))`
// inside the `analog` block and cite 7.3.7, the way E0430 lands on the call and
// cites 4.7.3 for the mirror rule. A refusal on the declaration is not this
// rule; it would also reject `08_analog_probe_in_a_digital_expression.va` and
// every other legal module that merely HAS a digital function.
//
// CITATION CORRECTED AFTER REVIEW. This paragraph and the `//! lrm` line below
// said §4.7.2 and called it "digital function declarations". §4.7.2 is
// *Returning a value from an analog user-defined function* — four subclauses
// about the implicit function-identifier variable, `return`, and output/inout
// arguments, none of which says a digital function may be declared. The
// sentence that does is in §4.7 itself, quoted above. Opened in
// `specification/ch4-expressions.html`.
//
// THE FUNCTION IS DELIBERATELY INNOCENT. `dig_helper` doubles a real and
// touches nothing else: no delay, no event, no four-state value, nothing that
// could be refused for a second reason. So the only thing left to reject is
// what §7.3.7 says, and a diagnostic that fires for any other reason is a
// masked verdict rather than a pass.
//
// This is one of only two rejections in row M01; the other eleven fixtures are
// positive.
//
//! lrm 7.3.7
//! lrm 4.7
//! lrm 7.3.7:1000
//! reject-only E0436
//! neighbour functions_called_from_their_own_context.va
`include "disciplines.vams"
module m01_digital_function_from_analog(p);
  inout p;
  electrical p;
  real y;

  function real dig_helper(input real x);
    begin
      dig_helper = x * 2.0;
    end
  endfunction

  analog begin
    y = dig_helper(V(p));
    I(p) <+ y;
  end
endmodule
