// §5.10.3.1: "If expr_tol is specified, time_tol shall also be specified".
// §7.3.5 puts the arguments of this digital event control in the continuous
// context, so the same prohibition applies as in an analog block. Direction
// and expr_tol are valid; only time_tol is missing. The neighboring runtime
// fixture event_bounds_mixed_legal.va supplies both and observes the crossing.
//! lrm 5.10.3.1
//! lrm 7.3.5
//! lrm 5.10.3.1:6
//! reject-only E0517
//! neighbour event_bounds_mixed_legal.va
`include "disciplines.vams"
module event_bounds_digital_cross_missing_time(p);
  inout p; electrical p;
  integer n;
  initial n = 0;
  always @(cross(V(p), 1, , 1m)) n = n + 1;
  analog I(p) <+ 0.0;
endmodule
