// §7.8: "Each connect statement designates a module to be a connect module.
// When two disciplines are specified in a connect statement, one shall be
// discrete and the other continuous." `ch7_nd_nowhere` below is declared
// nowhere, here or in Annex D's disciplines.vams, so it is neither: the
// statement names no Table 7-2 pair and bridges nothing. That is refused by
// name rather than skipped, which would leave every port it was written for
// to a later "no connect statement bridges them".
//
// The legal neighbour overrides with two declared disciplines of the two
// domains: discipline_and_direction_overrides.va.
//
//! lrm 7.8
//! lrm 7.8:2
//! lrm 7.7.1
//! reject-only E0923
//! neighbour discipline_and_direction_overrides.va

`include "disciplines.vams"
connectmodule ch7_nd_cm(el, cm);
  input el;
  output cm;
  electrical el;
  ddiscrete cm;
  reg cm;
  analog I(el) <+ V(el) / 1000.0;
  initial cm = 1'b0;
endmodule

module ch7_nd_top;
  electrical a;
  analog I(a) <+ V(a) / 1000.0;
endmodule

connectrules ch7_nd_rules;
  connect ch7_nd_cm ch7_nd_nowhere, ddiscrete;
endconnectrules
