// VAMS §7.8.4: "A connection shall be selected for a port only if one of the
// connections to the port is digital and the other is analog. In this case,
// the port shall match one (and only one) connect statement." IEEE 1364-2005
// §7.1.6: a terminal as wide as an instance array gives each element one bit.
//
// So in `and g[1:0] (y, a, b)` with `electrical [1:0] a`, element g[1]'s in1
// is the analog bit a[1] and g[0]'s is a[0]: two mixed ports, each needing a
// bridge on ONE BIT of `a`. VerA's connect insertion bridges a primitive
// terminal that is a whole scalar net; it does not insert a connect module on
// a bit of a vector, nor on a part select (`and (y, a[1], b)`), nor at a
// primitive in a generate block, nor on a switch instance array. Leaving
// such a terminal joined to the analog node would be a silent wrong answer
// (the gate reads a node no bridge converts), so it is refused by name:
// E0929, "a mixed port's connect module cannot be inserted".
//
// The legal neighbour is the same design with `a` scalar,
// prim_connect_gate_array.va, where each element gets its own bridge.
//
//! lrm 7.8.4
//! lrm 7.8.4:2
//! lrm 7.8.5.1
//! reject-only E0929
//! neighbour prim_connect_gate_array.va
`include "disciplines.vams"
`timescale 1ns/1ns

connectmodule b5_pvt_a2d(el, cm);
  input el;
  output cm;
  electrical el;
  ddiscrete cm;
  reg cm;
  analog I(el) <+ V(el) / 1000.0;
  initial cm = 1'b1;
endmodule

`default_discipline ddiscrete
module b5_prim_connect_vector_terminal_rejected;
  electrical [1:0] a;
  wire [1:0] y;
  reg [1:0] b;

  and g[1:0] (y, a, b);

  analog I(a[1]) <+ V(a[1]) / 1000.0;
endmodule
`default_discipline

connectrules b5_pvt_rules;
  connect b5_pvt_a2d split;
endconnectrules
