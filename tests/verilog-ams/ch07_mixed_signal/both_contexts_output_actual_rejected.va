// §7.2.2 contexts: "It shall be an error to assign to a given variable in both
// contexts." The sibling both_contexts_assignment_rejected.va provokes it with
// an assignment STATEMENT in each context. Here the continuous-context write is
// an output actual, which §4.7.2.3 defines as an assignment: "the last value
// assigned to the output argument is then assigned to the corresponding analog
// variable reference that was passed into the function."
//
// So `sampled` is assigned by the `initial` block (discrete) and by the call
// `d = grab(V(p), sampled);` (continuous), and the rule fires exactly as it does
// for `sampled = V(p);`. A checker that looked only at assignment targets
// accepted this file, and the analog write then silently owned a variable the
// discrete context also owns.
//
//! lrm 7.2.2
//! lrm 7.2.2:1
//! lrm 4.7.2.3
//! reject-only assigned in both contexts
//! reject E0432
`include "disciplines.vams"
module ch7_both_contexts_output(p);
  inout p; electrical p;
  real sampled, d;

  analog function real grab;
    input x; output y;
    real x, y;
    begin
      y = x;
      grab = x;
    end
  endfunction

  initial sampled = 1.25;
  analog begin
    d = grab(V(p), sampled);
    I(p) <+ sampled;
  end
endmodule
