// §7.8.5 gives auto-inserted connect modules generated instance names, so a
// parameter inside one can be reached by hierarchical `defparam`: merged
// insertion spells the name SigName__ModuleName__BottomDiscipline, split
// insertion spells it SigName__InstName__PortName.
//
// The naming convention itself is NOT tested here and cannot be. It lives
// entirely in the identifier TEXT, which no compiler interprets — a parser sees
// one identifier either way — so a fixture per spelling would be the same test
// twice. (connect_generated_split_name_unsupported.va was exactly that
// duplicate and was deleted; only the identifier differed.) What is testable is
// the verdict, and it is the same for both spellings.
//
// What settles it is the INSTANCE, not the keyword. §7.8.5's generated name
// exists only where a connect module was auto-inserted, which needs a
// `connectrules` block and a mixed-domain net — neither is here, and VerA has no
// auto-insertion at all (the block PARSES now, §7.7/A.1.8, but §7.8's insertion
// phase needs the discrete kernel the emitted analog device lacks). §6.3.1
// puts a defparam's target "in any module instance throughout the design"; this
// design has no instances, so the path names nothing.
//
// The reject line was E0205 "unsupported module item", on the ground that
// `defparam` is not an analog-subset module item. That ground is gone: §6.3.1
// defines the parameter_override, A.1.4 makes it a module_or_generate_item, and
// annex_a_syntax/defparam.va requires a conforming compiler to ACCEPT one —
// the two files cannot both be right about the KEYWORD. They can both be right
// about this file, because a defparam onto an instance that does not exist is
// refused whatever the subset. Same verdict, and now for the reason the clause
// actually gives: E0907, the override names no parameter of the design.
//
//! lrm 7.8.5
//! lrm 6.3.1
//! reject-only E0907
//! neighbour ../../verilog-a/annex_a_syntax/defparam.va
module ch7_connect_generated_defparam;
  defparam signal__converter__ddiscrete.threshold = 0.6;
endmodule
