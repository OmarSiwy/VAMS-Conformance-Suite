// "A mixed signal can have a number of compatible continuous nets, with
// different continuous disciplines and different abstols. In this case, the
// abstol of the associated node shall be the smallest of the abstols specified
// in the disciplines associated with all the continuous nets of the signal."
// §7.2.4
//
// The top's p and the child's bound p are segments of one signal, with
// potential abstols 10u and 100n. Their shared solver node must publish
// min(10u, 100n) = 100n. §5.5.3 still reads each segment's local nature
// attribute, so the parent's is 10u and the child's is 100n. Their flow
// attributes likewise remain 1p and 10f. The 1.5 V bias reaches both segments.
// The host metadata check, four local attributes and the voltage give six
// verdicts. No invalid value is needed for this minimum rule;
// compatible_disciplines_without_resolveto_rejected.va covers the separate
// refusal in §7.2.4's second paragraph.
// An older fixture joined p and q with a resistor. Those are different nodes,
// so its voltage check provided no evidence of a shared node's minimum.
//
//! lrm 7.2.4
//! lrm 7.2.4:1
//! lrm 5.5.3
//! lrm 7.2.3
//! lrm 7.2.3:1000
//! bias V(p) = 1.5
//! abstol p = 1e-7
//! checks 6
// Own base natures below: D.1's guard keeps annex D's out of check.vh's include.
`define DISCIPLINES_VAMS 1
`include "check.vh"
nature voltage_base;
  units = "V";
  access = V;
  abstol = 1u;
endnature
nature voltage_loose : voltage_base;
  abstol = 10u;
endnature
nature voltage_tight : voltage_base;
  abstol = 100n;
endnature
nature current_base;
  units = "A";
  access = I;
  abstol = 1p;
endnature
nature current_tight : current_base;
  abstol = 10f;
endnature
discipline disc_loose_tol;
  potential voltage_loose;
  flow current_base;
enddiscipline
discipline disc_tight_tol;
  potential voltage_tight;
  flow current_tight;
enddiscipline
module lrm_7_2_4_leaf(p);
  inout p; disc_tight_tol p;
  analog begin
    `CHECKR("the child keeps its local potential attribute", p.potential.abstol, 1e-7, 1e-12);
    `CHECKR("the child keeps its local flow attribute", p.flow.abstol, 1e-14, 1e-12);
    I(p) <+ V(p) * 0.0001;
  end
endmodule
module lrm_7_2_4_mixed_signal(p);
  inout p; disc_loose_tol p;
  lrm_7_2_4_leaf child(p);
  analog begin
    `CHECKX("the shared node has the prescribed bias", V(p), 1.5);
    `CHECKR("the parent keeps its local potential attribute", p.potential.abstol, 1e-5, 1e-12);
    `CHECKR("the parent keeps its local flow attribute", p.flow.abstol, 1e-12, 1e-12);
    I(p) <+ V(p) * 0.001;
  end
endmodule
