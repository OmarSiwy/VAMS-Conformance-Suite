// §7.3.2 accessing X and Z bits of a discrete net in a continuous context. The
// chapter's `converter` example annotates this exact contribution as illegal:
//
//     V(anet) <+ 1'bz;      // error
//
// and states the rule above it: "Accessing digital net and digital binary
// constant operands are supported within analog context expressions. It is an
// error if these operands return x or z bit values when solved."
//
// A z has no potential to contribute, so the branch has no value — this is an
// error in Verilog-AMS HDL, not merely outside the Verilog-A subset, and the
// rejection is conformance in both dialects. C.3 adds the subset half:
// "support for x and z values is limited in the analog block to the mixed
// signal context".
//
// The chapter already has fixtures for the ASSIGNMENT form of this rule
// (x_literal_unsupported.va, z_literal_unsupported.va, both `state = 1'bN;`);
// contribution is the other lvalue the example marks, and had none.
//
//! lrm 7.3.2
//! lrm 7.3.2:2
//! lrm C.3
//! reject-only E0130
`include "disciplines.vams"
module ch7_xz_contribution(p);
  inout p; electrical p;
  analog V(p) <+ 1'bz;
endmodule
