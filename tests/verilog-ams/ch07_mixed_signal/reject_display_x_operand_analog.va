// §7.3.2: "Accessing digital net and digital binary constant operands are
// supported within analog context expressions. It is an error if these
// operands return x or z bit values when solved." Its `converter` example
// marks `var1 = 1'bx; // error`. The subsection lists the only constructs
// that may meet x/z in an analog block (===, !==, case/casex/casez and the
// x/z digits they compare against); a $display argument is an ordinary
// operand, so `1'bx` there is an x value reaching an analog expression and
// is an error (specification/Vague_Decisions.md VD-017). IEEE 1364-2005 17.1.1.4's x
// formatting still governs the digital context
// (ieee1364/17_system_tasks/display_unknown_radix.v).
//
// VerA refuses it with E0130. Legal neighbour:
// display_binary_operand_analog.va, the same call with `1'b1`.
//! lrm 7.3.2
//! lrm 7.3.2:2
//! reject-only E0130
//! neighbour display_binary_operand_analog.va
//! neighbour ../../verilog/17_system_tasks/display_unknown_radix.v
`include "disciplines.vams"
module reject_display_x_operand_analog(p);
  inout p; electrical p;
  analog begin
    $display("%b", 1'bx);
    I(p) <+ V(p);
  end
endmodule
