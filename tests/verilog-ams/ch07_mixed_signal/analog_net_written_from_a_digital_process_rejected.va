// §7.3, the sentence that governs this whole row:
//
//   "In Verilog-AMS HDL, the nets and variables of one domain can be referenced
//    in the other's context. This is the means for passing information between
//    two different domains (continuous and discrete). Read operations of nets
//    and variables in both domains are allowed from both contexts. WRITE
//    OPERATIONS OF NETS AND VARIABLES ARE ONLY ALLOWED FROM THE CONTEXT OF
//    THEIR DOMAIN."
//
// Every other fixture in M01 exercises the read half. This one is the write
// half, and it is the reason the read half is safe to implement: if a digital
// process could contribute to a branch, the two kernels would both own the
// node's equation and §7.2.1's assignment of potentials and flows to the
// continuous domain would mean nothing.
//
// §7.3.3's own wording draws the same line from the other side — "All
// continuous nets can be PROBED from a discrete context using access
// functions", probed, not driven — and Syntax 7-3's `event_expression` admits
// analog events into a digital sensitivity list without admitting contribution
// into a digital statement.
//
// WHY THIS IS NOT ALREADY COVERED. E0432 ("variable assigned in both
// contexts", §7.2.2) is a different rule: it is about a VARIABLE with two
// writers, and it fires only when both writers exist. Here there is exactly one
// writer and it is in the wrong domain, so no both-contexts conflict arises and
// nothing in §7.2.2 applies. The rule broken is §7.3's, and the diagnostic has
// to say so.
//
// WHAT USED TO FAIL, and why it was not a pass: `error[E0205]: unsupported
// module item: found `always``. VerA refused the block, so it never judged the
// contribution inside it — the same masking that makes
// `digital_probe_unsupported.va` (since withdrawn to m01_08) uncredited
// for §7.3.3. As of 2026-09-21 the contribution is judged on its own terms
// (E0435) and the clause is pinned whether or not the block is executable —
// which is the point, because §7.3 holds in a compiler that supports `always`
// perfectly, while E0205 is a statement about VerA. The E0205 still arrives
// alongside; when `always` becomes executable (fixtures 06, 08, 09 and 10 all
// require it) this file is what stops the contribution coming with it.
//
// The clock is a plain reg toggled once, with no `#` delay, so the fixture does
// not additionally depend on the discrete timeline: the rule is decidable from
// the source.
//
//! lrm 7.3
//! lrm 7.2.1
//! lrm 7.2.3
//! lrm 7.2.3:1000
//! lrm 7.3:1000
//! reject-only E0435
`include "disciplines.vams"
module m01_contribution_from_digital(p);
  inout p;
  electrical p;
  reg clk;

  initial clk = 1'b1;

  always @(posedge clk)
    V(p) <+ 1.0;

  analog
    I(p) <+ 0.0;
endmodule
