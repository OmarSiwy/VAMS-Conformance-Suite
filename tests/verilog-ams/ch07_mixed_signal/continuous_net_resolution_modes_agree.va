// §7.4.5, verbatim: "The discipline of nets, without a declared discipline, of
// a continuous signal shall also be determined by using the discipline
// resolution algorithms listed in Annex F. Both algorithms will give the same
// result as there are no discrete disciplines to propagate upwards."
//
// §7.4.4 makes basic "the default" and leaves only the SELECTION of a mode
// vendor-specific, so a fixture that pins basic mode with no selection tests
// the normative default (basic_resolution_continuous_beats_discrete.va), and detail mode is testable once
// selected (Vague_Decisions VD-008; VerA's selector is
// `--discipline-resolution=detail`, whose top-down pass decides Figure 7-4
// differently: discipline_resolution_detail_figure_7_4.va). §7.4.5 is
// the case where the modes cannot disagree, because there is nothing discrete
// in the design for them to propagate differently. Every net below is
// continuous, so both algorithms must land on the same discipline.
//
// THE NUMBER IS THE NET'S OWN NATURE ATTRIBUTE, read through §5.5.3 Syntax 5-4
// — `net_identifier . potential_or_flow . nature_attribute_identifier`, the one
// expression in the language that names a nature attribute. It is the right
// probe for this clause and not a proxy for something else: the clause's whole
// content is WHICH DISCIPLINE the net ends up with, the discipline is what binds
// the nature, and the nature is what carries `abstol`. Give the discipline under
// test a potential nature whose `abstol` is distinguishable from every built-in
// one and the resolved discipline is then a number.
//
//     ch745_alt.potential is `ch745_pot`, whose abstol = 1n = 1e-9 V
//     electrical's potential nature (§3.6.1.2's default) has abstol = 1u = 1e-6 V
//
// The nature declares `abstol = 1n` and the assertion writes `1e-9`: the two
// spellings are one double, so the comparison is exact either way, and the want
// is in exponent form only because §2.5's scale factors are not part of the
// literal grammar the assertion lint accepts. Nothing about the test turns on
// which spelling is used on which side.
//
// `undec` is undeclared and meets exactly one port, `ch745_child`'s, which is
// declared `ch745_alt`. Annex F has one candidate discipline to assign and both
// algorithms assign it, so the answer is 1e-9. A compiler that hard-coded the
// common shortcut — an undeclared net is electrical — reads 1e-6, three orders
// of magnitude away, and one that left the net with no discipline at all has no
// nature to read here. Neither is within any tolerance this comparison could be
// given, so CHECKX with the exact literal is right: both numbers are exact
// powers of ten, parsed by the same lexer that produced the source.
//
// WHAT THIS DOES NOT CLAIM. §6.5.8 says a NODE's tolerance is the smallest over
// all disciplines associated with it, and a node can be associated with several
// nets. This reads ONE net's own nature — the discipline resolution gave that
// net — and is silent about any minimum over a node's associations. §7.4.4.3
// carries the other half of resolution, coercion by declaration, and has its own
// fixture; nothing here is declared.
//
//! lrm 7.4.5
//! lrm 7.4.5:1
//! bias V(undec) = 0.5
//! print none
// Own base natures below: D.1's guard keeps annex D's out of check.vh's include.
`define DISCIPLINES_VAMS 1
`include "check.vh"
nature ch745_pot;
  units = "V";
  access = V;
  abstol = 1n;
endnature

nature ch745_flo;
  units = "A";
  access = I;
  abstol = 1p;
endnature

discipline ch745_alt;
  domain continuous;
  potential ch745_pot;
  flow ch745_flo;
enddiscipline

module ch745_top;
  ch745_child c(undec);

  analog begin
    `CHECKX("an undeclared continuous net takes the discipline that reaches it",
            undec.potential.abstol, 1e-9);
    `CHECKX("and the bias put the net where the clause says it is", V(undec), 0.5);
    I(undec) <+ 0.0;
  end
endmodule

module ch745_child(port);
  inout port;
  ch745_alt port;
endmodule
