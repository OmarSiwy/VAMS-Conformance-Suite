// §7.2.4: a node's abstol is the minimum of all continuous net segments
// of its signal. Each top-level net has 1e-6; the child's discipline overrides
// its nature's 1e-8 with 1e-9 (§3.6.2.3), so the child's ports have 1e-9.
// The vector binding joins both a elements to tight segments. The second
// binding joins b and ground through a concatenation, so b also gets 1e-9.
// The separate spare net stays at 1e-6: a module-wide minimum would be wrong.
// Ground contributes no solver unknown. Four host metadata checks, five
// binary-exact voltage checks and one local nature read in each of the two
// child instances give eleven verdicts at one declared bias point.
// This is the minimum rule's positive form; the incompatible/no-resolveto
// fixtures in this directory pin its distinct invalid discipline bindings.
//! lrm 7.2.4
//! lrm 5.5.3
//! lrm 8.3.3
//! lrm 8.3.3:2
//! lrm 6.5.8
//! lrm 6.5.8:3
//! lrm 7.2.4:1
//! bias V(a[0]) = 0.5
//! bias V(a[1]) = 1.5
//! bias V(b) = 2.5
//! bias V(spare) = 3.5
//! abstol a[0] = 1e-9
//! abstol a[1] = 1e-9
//! abstol b = 1e-9
//! abstol spare = 1e-6
//! checks 11
// Own base natures below: D.1's guard keeps annex D's out of check.vh's include.
`define DISCIPLINES_VAMS 1
`include "check.vh"
nature min_tol_voltage;
  units = "V";
  access = V;
  abstol = 1e-6;
endnature
nature min_tol_tight : min_tol_voltage;
  abstol = 1e-8;
endnature
nature min_tol_current;
  units = "A";
  access = I;
  abstol = 1e-12;
endnature
discipline min_tol_loose;
  potential min_tol_voltage;
  flow min_tol_current;
enddiscipline
discipline min_tol_fine;
  potential min_tol_tight;
  flow min_tol_current;
  potential.abstol = 1e-9;
enddiscipline
module min_tol_leaf(p);
  inout [1:0] p;
  min_tol_fine [1:0] p;
  analog `CHECKR("the vector port keeps its local nature", p.potential.abstol, 1e-9, 1e-12);
endmodule
module node_abstol_vector_ports(a, b, spare);
  inout [1:0] a;
  inout b, spare;
  min_tol_loose [1:0] a;
  min_tol_loose b, spare, g;
  ground g;
  min_tol_leaf vector_binding(a);
  min_tol_leaf concat_binding({b, g});
  analog begin
    `CHECKX("a[0] retains its own bias", V(a[0]), 0.5);
    `CHECKX("a[1] retains its own bias", V(a[1]), 1.5);
    `CHECKX("b retains its own bias", V(b), 2.5);
    `CHECKX("the unconnected spare retains its own bias", V(spare), 3.5);
    `CHECKX("ground has zero potential", V(g), 0.0);
    I(a[0]) <+ V(a[0]);
    I(a[1]) <+ V(a[1]);
    I(b) <+ V(b);
    I(spare) <+ V(spare);
  end
endmodule
