// §7.4.3 connection of continuous-time disciplines: "Ports of continuous-time
// disciplines (ports where analog signals appear at both upper (vpiHiConn) and
// lower (vpiLoConn) connections) shall obey the rules imposed in 3.11. It shall
// be an error to connect incompatible continuous disciplines together."
// §3.11's Signal Connection Rule says the same of any connection: "It shall be
// an error to connect two ports or nets of the same domain with incompatible
// disciplines."
//
// The pair is taken from §3.11.1's own worked example, which rules on it by
// name: "electrical and rotational are incompatible disciplines because the
// natures for both potential and flow are not derived from the same base
// natures." Both are continuous (they bind natures, §3.6.2.2), so this is the
// same-domain case the rule covers and not a connect-module question (§7.4.4).
//
// incompatible_disciplines_rejected.va pins the in-module form (an access
// function over two nets). This file pins the PORT form §7.4.3 is about: the
// upper connection `p` is declared electrical, the lower connection, port `a`
// of `u`, is declared rotational, and nothing else in the file is wrong.
// compatible_port_discipline.va is the positive half.
//
//! lrm 7.4.3
//! lrm 7.4.3:1
//! lrm 7.4.3:2
//! lrm 3.11
//! lrm 3.11.1
//! lrm 3.11:4
//! lrm 3.11.1:1
//! reject-only E0355
//! reject rotational
//! neighbour compatible_port_discipline.va
`include "disciplines.vams"
module ch07_incompatible_port_child(a);
    inout a;
    rotational a;
endmodule

module ch07_incompatible_port_discipline_rejected(p, n);
    inout p, n;
    electrical p, n;
    ch07_incompatible_port_child u(p);
    analog I(p, n) <+ V(p, n) * 1.0e-3;
endmodule
