// §7.3.2 accessing X and Z bits in a continuous context. The chapter's own
// `converter` example annotates this exact line as illegal:
//
//     var2 = 1'bz;          // error
//
// `var2` is declared `real` there, so the target below is real too — the
// example's other annotated line, `var1 = 1'bx`, assigns to an `integer` and is
// x_literal_unsupported.va. Between them the pair covers both the z and the x
// literal AND both destination types the example uses.
//
// The rule above it says why: "it is an error if these operands return x or
// z bit values when solved". A z has no real or integer value to assign, so the
// assignment below is an error in Verilog-AMS HDL as well as in Verilog-A —
// this rejection is conformance in both dialects, not a subset limitation.
// C.3 narrows it further for this one: "support for x and z values is limited
// in the analog block to the mixed signal context".
//
//! lrm 7.3.2
//! lrm 7.3.2:2
//! lrm C.3
//! reject-only E0130
`include "disciplines.vams"
module ch7_z_literal(p);
  inout p; electrical p; real var2;
  analog begin var2 = 1'bz; I(p) <+ var2; end
endmodule
