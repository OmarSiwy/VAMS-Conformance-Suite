// §9.7 Simulation Control System Tasks, third paragraph verbatim:
//
//   "Verilog AMS HDL also supports three new simulation control tasks in the
//    analog context only; $fatal, $error, $warning."
//
// The same rule is a TABLE, and the table is the one with teeth. §9.7 is the
// subclause of Table 9-4, "Simulation Control System Tasks" (printed p.217):
//
//     $finish    Yes  Yes
//     $stop      Yes  Yes
//     $fatal     No   Yes
//     $warning   No   Yes
//     $error     No   Yes
//     $info      No   Yes
//
// Four of the six rows have a digital "No" and an analog "Yes", and this file is
// the digital half of that column. The analog half is 057/058/059/060, 13 and
// 173, and it is the half that works: those four tasks in an `analog` block are
// accepted, print, and (for $fatal) terminate. The clause's digital "No" is the
// half nothing pinned, because the four analog fixtures never call one from
// anywhere else.
//
// SO THE RULE ON TRIAL IS A CALL SITE, and it needs no netlist and no runtime:
// an `initial` block is the discrete (digital) context per §7.2.2, and a
// severity task written there is a row of Table 9-4 whose digital cell is No.
//
// WHY THIS IS A REJECT AND NOT AN ASSERTION. The requirement is a diagnostic —
// the construct is not supported here — so the verdict is "must not compile" and
// there is no `want` to write. Same shape as 153_file_io_digital_only_analog_-
// rejected.va, which is this file's mirror image: a Table 9-2 analog "No" column
// refused at the call site with `analog context` in the message.
//
// WHAT USED TO HAPPEN. VerA refused this file, but not for Table 9-4's reason:
// every statement in an `initial` block was E0433, "only assignments of
// constant expressions are supported here", §7.2.2's initial-block ceiling,
// which fires identically for `x = 1;`. A user who wrote $error in a digital
// context was told their initial block was too complicated, not that §9.2's
// table has no Yes for it. Each call is now E0821, "system task is not
// supported in the digital context" — the E0806 family's digital twin — and
// E0433 no longer fires on top of it.
//
//! lrm 9.2
//! lrm 9.7
//! lrm 9.7.3
//! lrm 9.2:1000
//! lrm 9.7:1000
//! reject-only E0821
//! neighbour ../../verilog-a/ch09_system_tasks/simulation_control_in_analog_context.va
`include "disciplines.vams"
module ch09_severity_task_digital_context_rejected(p, n);
  inout p, n; electrical p, n;
  initial begin
    $fatal(1, "fatal");
    $error("error");
    $warning("warning");
    $info("info");
  end
  analog begin
    I(p,n) <+ V(p,n);
  end
endmodule
