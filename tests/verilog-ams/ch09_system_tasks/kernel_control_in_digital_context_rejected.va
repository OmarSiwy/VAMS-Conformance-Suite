// §9.17: "Verilog AMS HDL adds a set of tasks and functions to control the
// analog solver's behavior on a signals and instances called the analog kernel
// control tasks." They control the ANALOG SOLVER, and §9.2 Table 9-14 says so
// cell by cell:
//
//   Task/function name | Supported in digital context | Supported in analog context
//   $discontinuity     | No                           | Yes
//   $limit             | No                           | Yes
//   $bound_step        | No                           | Yes
//
// A digital process has no timestep to bound and no Newton iterate to limit.
// §7.2.2 makes an `always` block the discrete context, so `$bound_step` there
// breaks Table 9-14's first column. The same call in the analog block is
// kernel_control_tasks_together.va, which compiles and runs.
//
// VerA reports E0821 "system task is not supported in the digital context".
//
//! lrm 9.17
//! lrm 9.2
//! lrm 9.2:1000
//! reject E0821
//! reject `$bound_step` in an always block
//! neighbour ../../verilog-a/ch09_system_tasks/kernel_control_tasks_together.va
`include "disciplines.vams"
module ch09_kernel_control_in_digital_context(p, n);
  inout p, n; electrical p, n;
  reg clk;
  always @(clk) $bound_step(1.0e-6);     // illegal: Table 9-14 digital cell is No
  analog I(p, n) <+ V(p, n);
endmodule
