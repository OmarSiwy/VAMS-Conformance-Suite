// A.6.5 derives `driver_update` in any digital event expression:
//
//     event_expression ::= ... | driver_update expression             // A.6.5
//
// and §9.22 fences it to connect modules: "Driver access functions can only
// be called from connect modules", and driver_update "is used in combination
// with the driver access functions" (§9.22's opening paragraph names the
// family "Connectmodule Driver Access System Functions and Operator"). So the
// event below parses and is refused by that clause, E0818, the code the driver
// access functions get outside a connect module (107_..., 112_..., 114_...).
// The neighbour writes the same event in a connectmodule's `always`, where it
// is legal; driver_update_in_analog_event_rejected.va is the analog-event
// refusal (A.6.5's analog_event_expression has no driver_update at all).
//
//! lrm 9.22
//! lrm 9.22.5
//! lrm A.6.5
//! reject-only E0818
//! reject driver_update
//! neighbour driver_update_connectmodule.va
`include "disciplines.vams"
module ch09_driver_update_in_ordinary_module(p, n);
  inout p, n; electrical p, n;
  wire d;
  integer hits;
  always @(driver_update d) hits = hits + 1;  // illegal: not a connect module
  analog I(p, n) <+ V(p, n);
endmodule
