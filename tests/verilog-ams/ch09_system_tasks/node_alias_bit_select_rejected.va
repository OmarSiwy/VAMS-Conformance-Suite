// §9.20: "If the analog_net_reference is a vector node, it shall reference the
// FULL vector node, it shall be an error for it to be a bit select or part
// select of a vector node."
//
// The rule is about which matrix positions the alias moves. A vector node is a
// vector of matrix positions and the alias binds the whole set at once; a bit
// select names one of them, and the LRM's own validity rules make the OTHER
// side of the call the place where a scalar element is allowed ("The
// hierarchical_reference_string shall refer to a scalar continuous node or a
// scalar element of a continuous vector node"). So the asymmetry is deliberate:
// scalar element on the right, whole vector on the left.
//
// A reject, so there is nothing to run and no `want` to write.
//
//! lrm 9.20
//! lrm 9.20:2
//! reject-only bit select or part select
//! reject E0812
//! neighbour analog_node_alias.va
`include "disciplines.vams"
module ch09_node_alias_bit_select_rejected(p, n);
  inout p, n; electrical p, n;
  electrical [3:0] bus;
  integer status;
  analog initial begin
    status = $analog_node_alias(bus[1], "$root.top.a");
  end
  analog begin
    I(p,n) <+ V(p,n) + status;
  end
endmodule
