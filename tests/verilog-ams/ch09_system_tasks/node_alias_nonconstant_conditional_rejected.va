// §9.20: "The $analog_node_alias() and $analog_port_alias() system functions
// shall not be used inside conditional ( if , case , or ?: ) statements UNLESS
// the conditional expression controlling the statement consists of terms which
// CAN NOT CHANGE during the course of a simulation."
//
// So the rule is not "no conditionals" — a guard on a parameter is fine, and
// that is how the LRM expects a model to pick between two hierarchical strings.
// It is "no conditionals the simulation can move". `$abstime` is the plainest
// term that changes during the course of a simulation: the alias would exist
// after 0.5 s and not before it, and the circuit matrix would change shape
// mid-run — the same objection that confines these functions to analog initial
// in the first place.
//
// A node voltage would be the more obvious moving term, but §5.2.1 already bars
// access functions from an analog initial block, so a fixture written that way
// would be rejected for the wrong rule and pin nothing. $abstime is legal
// there and still not constant.
//
// This is the one of the six §9.20 rules whose violation is written in the
// CONTROL and not in the arguments; the call itself is the legal call from 105.
//
// A reject, so there is nothing to run and no `want` to write.
//
//! lrm 9.20
//! lrm 9.20:9
//! reject-only inside conditional
//! reject E0812
//! neighbour analog_node_alias.va
`include "disciplines.vams"
module ch09_node_alias_nonconstant_conditional_rejected(p, n);
  inout p, n; electrical p, n;
  electrical local_node; integer status;
  analog initial begin
    if ($abstime > 0.5)
      status = $analog_node_alias(local_node, "$root.top.a");
  end
  analog begin
    I(p,n) <+ V(p,n) + status;
  end
endmodule
