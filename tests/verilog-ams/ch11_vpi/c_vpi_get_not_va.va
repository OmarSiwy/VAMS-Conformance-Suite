// Source-audit correction: this HDL-only fixture does not execute VPI.
// Chapter 11's API and object model are exercised by the `.c` fixtures in
// build.zig's `vpi_runs`; only language clauses are credited here.
// §11.4 Tables 11-1/11-4 name `vpi_get` as a C VPI routine of the simulator
// host interface. Nothing makes it a Verilog-A function: it has no declaration
// in this source and no §9 system-function spelling (no leading `$`), so §4.7
// leaves it an ordinary call to an undeclared function, which is the error.
// The rule that travels to any compiler is §4.7; E0512 is VerA's code for it.
//
//! lrm 4.7
//! reject-only E0512
//! reject `vpi_get`
`include "disciplines.vams"
module ch11_c_vpi_get_not_va(p, n);
  inout p, n; electrical p, n;
  analog I(p,n) <+ vpi_get(1, 0);
endmodule
