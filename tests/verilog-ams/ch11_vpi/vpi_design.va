// The design `zig build test-vpi` walks from C. LRM §6.2.2 (instantiation),
// §11.6 (the object model the walk is against).
//
// Not a fixture, on purpose (no `//!` line, so the suite does not collect it):
// a fixture asserts a NUMBER a compiled device produces, and nothing here is
// about the device. This source exists to have a SHAPE — three levels of
// instance, a class of object at every level, and a distinct spelling for each
// property `vpi_app.c`, beside this file, reads:
//   - three scopes deep, so §11.6.1's `vpiInternalScope` is recursive rather
//     than one hop, and so §6.7's upward name search has somewhere to walk up
//     THROUGH rather than straight to the top;
//   - two module definitions used once each and a third used twice, so
//     §11.6.1's `vpiDefName` is a fact the walk can be wrong about, and so
//     §11.2.2's instance-uniqueness (`u1.w` and `u2.w` are two objects) has two
//     objects to be about;
//   - every §11.6 class VerA answers present in at least one scope: ports with
//     three different §6.5.2.2 directions, a scalar net and a §3.6.3 vector
//     one, a scalar `reg` and a packed one, and `parameter`/`localparam` of
//     both §3.4.1 types.
//
// The analog bodies are the minimum that makes each module a legal device:
// every declared port has to carry a contribution or the top would not
// elaborate, and what they compute is never read.

`include "disciplines.vams"
module vpi_top(p, n, en);
  inout p, n;
  input en;
  electrical p, n, en;

  parameter real gain = 2.0;
  localparam integer revision = 7;

  electrical mid;
  electrical [0:3] bus;
  reg [3:0] state;
  reg ready;

  vpi_mid u1(p, mid);
  vpi_mid u2(mid, n);

  analog begin
    I(p, n) <+ gain * V(p, n);
    I(en) <+ V(en);
  end
endmodule

// The middle level: one instance of its own, so the tree is three deep.
module vpi_mid(a, b);
  inout a;
  output b;
  electrical a, b;

  parameter real scale = 1.0;
  electrical inner;

  vpi_leaf v(a, b);

  analog I(a, b) <+ scale * V(a, b);
endmodule

module vpi_leaf(x, y);
  input x;
  output y;
  electrical x, y;

  parameter integer taps = 3;
  localparam real trim = 0.5;
  electrical deep;

  analog I(x, y) <+ taps * trim * V(x, y);
endmodule
