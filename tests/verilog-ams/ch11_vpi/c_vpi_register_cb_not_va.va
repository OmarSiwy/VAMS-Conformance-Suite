// Source-audit correction: this HDL-only fixture does not execute VPI.
// Chapter 11's API and object model are exercised by the `.c` fixtures in
// build.zig's `vpi_runs`; only language clauses are credited here.
// §11.2.1 registers a callback from C with `vpi_register_cb`. There is no
// Verilog-A spelling for it: the name has no declaration in this source and no
// §9 system-function spelling (no leading `$`), so §4.7 leaves it an ordinary
// call to an undeclared function, which is the error. The rule that travels to
// any compiler is §4.7; E0512 is VerA's code for it. (Contrast 08: `$name` IS
// grammatical per §2.8.3 and must NOT be rejected.)
//
//! lrm 4.7
//! reject-only E0512
//! reject `vpi_register_cb`
`include "disciplines.vams"
module ch11_c_vpi_register_cb_not_va(p, n);
  inout p, n; electrical p, n;
  analog I(p,n) <+ vpi_register_cb(0);
endmodule
