// A.2.6 and A.2.8:
//
//     analog_function_item_declaration ::=
//             analog_block_item_declaration
//             | input_declaration ; | output_declaration ; | inout_declaration ;
//     analog_block_item_declaration ::=
//             { attribute_instance } parameter_declaration ;
//             | { attribute_instance } integer_declaration
//             | { attribute_instance } real_declaration
//             | { attribute_instance } string_declaration
//
// A.2.8 also defines the digital block_item_declaration, which does include
// `reg`; the analog one does not. So `reg r;` inside an analog function is not
// derivable. `integer r;` in the same place compiles (probed).
//
// VerA reports E0209 "expected an expression: found `reg`".
//
//! lrm A.2.8
//! lrm A.2.6
//! lrm A.2.6:1000
//! lrm A.2.8:1000
//! reject-only E0209
//! neighbour ../../verilog-a/annex_a_syntax/analog_function.va
`include "disciplines.vams"
module annex_a_reg_in_analog_function(p, n);
  inout p, n;
  electrical p, n;

  analog function real f;
    input x;
    real x;
    reg r;                   // illegal: reg is not an analog_block_item_declaration
    f = x;
  endfunction

  analog I(p, n) <+ f(V(p, n));
endmodule
