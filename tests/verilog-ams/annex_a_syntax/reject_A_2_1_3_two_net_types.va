// A.2.1.3 opens a net declaration with one net_type:
//
//     net_declaration ::= net_type [ discipline_identifier ] [ signed ]
//             [ delay3 ] list_of_net_identifiers ; | ...
//     net_type ::= supply0 | supply1 | tri | triand | trior | tri0 | tri1
//             | uwire | wire | wand | wor                              // A.2.2.1
//
// After it comes an optional discipline_identifier, which a keyword is not, so
// `supply1 supply1 s1;` derives from nothing. The legal neighbour,
// net_and_variable_types.va, declares `supply1 s1;` among A.2.2.1's eleven
// net types.
//
// VerA refuses the second net type with E0207 and a message naming A.2.1.3's
// rule; both are pinned.
//
//! lrm A.2.1.3
//! lrm A.2.1.3:1000
//! reject-only E0207
//! reject-only names one net_type
//! neighbour net_and_variable_types.va
`include "disciplines.vams"
module annex_a_two_net_types(p, n);
    inout p, n;
    electrical p, n;

    supply1 supply1 s1;           // illegal: one net_type per declaration

    analog I(p, n) <+ V(p, n);
endmodule
