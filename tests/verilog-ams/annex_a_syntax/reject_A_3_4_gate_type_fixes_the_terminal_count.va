// A.3.4 is a list of names, and what makes it a rule is that each name is
// filed under exactly one class — and the class, not the name, is what A.3.1
// consults for the shape of an instance:
//
//     enable_gatetype ::= bufif0 | bufif1 | notif0 | notif1           // A.3.4
//     cmos_switchtype ::= cmos | rcmos
//     pass_en_switchtype ::= tranif0 | tranif1 | rtranif1 | rtranif0
//
//     enable_gate_instance ::= [ name_of_gate_instance ]              // A.3.1
//             ( output_terminal , input_terminal , enable_terminal )
//     cmos_switch_instance ::= [ name_of_gate_instance ] ( output_terminal ,
//             input_terminal , ncontrol_terminal , pcontrol_terminal )
//     pass_enable_switch_instance ::= [ name_of_gate_instance ]
//             ( inout_terminal , inout_terminal , enable_terminal )
//
// So `bufif0 g1 (y, a);` is two terminals where its class takes exactly three,
// `cmos g2 (y, a, nc);` is three where its class takes exactly four, and
// `tranif1 g3 (a, b);` is two where its class takes exactly three. Each line
// would be LEGAL under a different class — two terminals is a `buf`, three is
// an `nmos`, two is a `tran` — so a parser that read the terminal list without
// consulting A.3.4's classification would accept all three. That is why this
// is A.3.4's reject and not A.3.1's: reject_A_3_1_buf_with_one_terminal.va
// already pins a list too short for EVERY class.
//
// The positive side of the same classification is 56_gate_instantiation_
// unsupported.va (`and`, an n_input_gatetype, with two inputs) and
// primitive_strengths_unsupported.va (the pull gates); the three classes
// used here run under the discrete engine in `tests/fixtures/digital/`
// (gates_enable.v, switch_cmos.v, bidirectional.v).
//
// VerA refuses each instance at its own terminal list with E0209, and each
// message names the class: the enable-gate one from `parseGates`, the two
// switch ones from `parseSwitch`'s A.3.4 table. Each is pinned as its own
// substring, so dropping any one arm FAILs rather than passing on a neighbour.
// The W0252 on the gate line (a gate in an analog device computes nothing) is
// incidental and not pinned.
//
//! lrm A.3
//! lrm A.3.4
//! lrm A.3.1
//! lrm A.3.1:1000
//! lrm A.3.4:1000
//! reject-only E0209
//! reject an enable gate takes an output, a data input and an enable
//! reject cmos_switchtype
//! reject pass_en_switchtype
//! neighbour primitive_strengths_unsupported.va
`include "disciplines.vams"
module annex_a_gate_type_fixes_terminal_count(p, n);
    inout p, n;
    electrical p, n;
    wire y, a, b, nc;

    bufif0  g1 (y, a);        // illegal: enable_gatetype takes three terminals
    cmos    g2 (y, a, nc);    // illegal: cmos_switchtype takes four
    tranif1 g3 (a, b);        // illegal: pass_en_switchtype takes three

    analog I(p, n) <+ V(p, n);
endmodule
