// A.2.1.2:
//
//     input_declaration ::=
//             input [ discipline_identifier ] [ net_type | wreal ] [ signed ] [ range ]
//                 list_of_port_identifiers
//
// An input port may be a net (of a discipline, a net_type, or wreal); it may
// not be a variable, so `input real k` is not derivable. `input wire k` is
// accepted in the same position (probed).
//
// VerA reports E0208 "expected an identifier: found `real`". One thing this
// file does NOT establish: VerA gives the same E0208 for the LEGAL
// `input wreal k` (probed), so the refusal of `real` here is right but the
// parser's handling of this position is not complete. That is the positive
// half's gap, not this rule's.
//
//! lrm A.2.1.2
//! lrm A.2.1.2:1000
//! reject-only E0208
//! neighbour ../../verilog-a/annex_a_syntax/module_ports.va
`include "disciplines.vams"
module annex_a_input_real(p, n, k);
  inout p, n;
  electrical p, n;
  input real k;              // illegal: an input port is not a variable
  analog I(p, n) <+ V(p, n);
endmodule
