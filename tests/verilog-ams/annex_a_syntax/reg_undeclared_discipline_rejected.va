// A.2.1.3 `reg_declaration ::= reg [ discipline_identifier ] [ signed ]
// [ range ] list_of_variable_identifiers ;`: the identifier names a discipline
// declared with `discipline ... enddiscipline` (§3.6.2), as a net
// declaration's does (E0371). `nosuch` is declared nowhere, so the reg's
// discipline names nothing. The neighbour declares `reg logic [3:0] rl;`, with
// annex D.1's `logic`.
//
//! lrm A.2.1.3
//! lrm 3.6.2
//! reject-only E0371
//! reject nosuch
//! neighbour digital_declaration_forms_in_va.va
`include "disciplines.vams"
module reg_undeclared_discipline(p);
    inout p;
    electrical p;
    reg nosuch r;    // illegal: no discipline is named `nosuch`

    analog I(p) <+ V(p);
endmodule
