// A.6.9 `task_enable ::= hierarchical_task_identifier [ ( expression { , expression } ) ] ;`
// is an alternative of the DIGITAL A.6.4 `statement` only. The A.6.4
// `analog_statement` list has no `task_enable` alternative — its only call form
// is `analog_system_task_enable`, a `$`-prefixed system task. So `record(V(p));`
// in analog_statement position is underivable and a conforming tool diagnoses
// this module.
//
// WHICH DIAGNOSTIC IS PINNED, and why it is not E0205. The `task ... endtask`
// DECLARATION is LEGAL: A.1.4 `module_or_generate_item_declaration` admits
// `task_declaration`, A.2.7 defines it, and `input real x` there is a valid
// A.2.7 `tf_input_declaration` (`input task_port_type list_of_port_identifiers`
// with `task_port_type ::= integer | real | realtime | time`). VerA once
// refused it with E0205 "unsupported module item: found task"; it accepts it
// now (task_declaration_enabled_from_initial.va is the positive half).
//
// This file used to pin that E0205 — a diagnostic fired on source the LRM makes
// legal — which meant the A.6.4 rule it claims to test was never reached, and a
// conforming tool that parsed the declaration and diagnosed only the enable
// FAILED the fixture. It now pins E0214, the error VerA reports at the enable
// itself (`record(V(p))` parsed as an lvalue, then "expected '<+' or '='"),
// So the pinned code is the one that belongs to the rule in the header.
//
//! lrm A.6.9
//! lrm A.6.4
//! lrm A.2.7
//! lrm A.6.4:1000
//! reject-only E0214
//! neighbour task_declaration_enabled_from_initial.va
`include "disciplines.vams"
module annex_a_task_enable(p); inout p; electrical p; task record; input real x; begin $display("%g",x); end endtask analog begin record(V(p)); I(p)<+V(p); end endmodule
