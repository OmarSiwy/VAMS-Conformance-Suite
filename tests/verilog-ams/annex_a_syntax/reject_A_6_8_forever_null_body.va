// A.6.8, the digital loop:
//
//     loop_statement ::= forever statement
//             | repeat ( expression ) statement | ...
//
// The body is `statement`. The null statement is an alternative of
// `statement_or_null` only, which A.6.8 does not name, so `forever ;` is not
// derivable. It is also a process that can never suspend: nothing in the body
// consumes simulation time, so the loop would hold the simulator at t = 0.
//
// The legal form is a body with a timing control, which
// annex_g_change_history/forever_is_a_digital_loop.va runs:
// `forever #1 ticks = ticks + 1;`. The analog forever is a different refusal
// (E0209, annex_g 04): G.2.1 retired it and `analog_loop_statement` has no
// forever arm at all.
//
// VerA refuses the null body with E0296 at the `;`; the code is pinned.
//
//! lrm A.6.8
//! lrm A.6.8:1000
//! reject-only E0296
//! neighbour ../annex_g_change_history/forever_is_a_digital_loop.va
`include "disciplines.vams"
module annex_a_forever_null_body(p, n);
    inout p, n;
    electrical p, n;

    initial forever ;          // illegal: `statement`, not `statement_or_null`

    analog I(p, n) <+ V(p, n);
endmodule
