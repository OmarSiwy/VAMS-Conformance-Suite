// A.6.3 `par_block ::= fork [ : block_identifier ... ] { statement } join` is
// an alternative of the digital A.6.4 `statement`. A.6.4 `analog_statement`
// offers `analog_seq_block` (begin/end) and nothing else in that slot: analog
// behaviour is one ordered evaluation of a single block (§5.2/§5.3.1), so there
// is no meaning for two analog statements running concurrently.
//
// Suite-wide the only `fork` before this was annex_b_keywords/task_control_keywords.va,
// which puts it inside a `task` and so never reaches an analog context.
//
// Sibling files 33 (wait) and 34 (delay control) cover the other two digital
// timing statements. They cannot share one file: a `//! reject` fixture stops
// at the first diagnostic.
//
// E0249 names A.6.3; until 2026-10 this was the parser's generic E0209. The
// legal neighbour, `fork ... join` in an `initial` block, runs in
// digital_statements_in_initial.va.
//
//! lrm A.6.4
//! lrm A.6.3
//! lrm 5.3.1
//! lrm A.6.3:1000
//! lrm A.6.4:1000
//! reject-only E0249
//! neighbour digital_statements_in_initial.va
`include "disciplines.vams"
module annex_a_fork_in_analog(p); inout p; electrical p; real x;
analog begin fork x = 1.0; join I(p) <+ x * V(p); end
endmodule
