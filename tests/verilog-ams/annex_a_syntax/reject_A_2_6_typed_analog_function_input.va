// A.2.6 gives an analog function A.2.1.2's port declarations as items:
//
//     analog_function_item_declaration ::= analog_block_item_declaration
//             | input_declaration ; | output_declaration ; | inout_declaration ;
//     input_declaration ::= input [ discipline_identifier ]
//             [ net_type | wreal ] [ signed ] [ range ] list_of_port_identifiers
//
// No data type follows `input`: 4.7.1 types a formal by "an associated block
// item declaration". `input real x;` is IEEE 1364-2005's tf_input_declaration,
// which a task or a digital `function` takes and an analog function does not.
// The legal neighbour writes `input x; real x;`.
//
// VerA refuses the typed direction with E0291; the code is pinned. The one
// typed direction A.2.1.2 derives, `output integer`, stays legal.
//
//! lrm A.2.6
//! lrm A.2.6:1000
//! lrm 4.7.1
//! reject-only E0291
//! neighbour ../../verilog-a/annex_a_syntax/analog_function_formal_typed_by_item.va
`include "check.vh"
module annex_a_function_formal_typed(p, n);
    inout p, n;
    electrical p, n;

    analog function real twice;
        input real x;             // illegal: the type is a separate item
        twice = 2.0 * x;
    endfunction

    analog begin
        `CHECKX("twice(V(p, n)), x typed by its own item", twice(V(p, n)), 1.0);
        I(p, n) <+ V(p, n);
    end
endmodule
