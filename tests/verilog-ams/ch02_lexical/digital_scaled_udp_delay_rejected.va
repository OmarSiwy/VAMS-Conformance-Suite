// AMS §2.6.2 forbids a scaled literal in a UDP's digital delay. Named UDP
// instances initially have the same syntax as module parameter overrides;
// resolving the name must apply the delay restriction even when expression
// folding discards the operand containing the scale factor.
// Legal neighbours: digital/digital_delay_primitive_notation.v executes a
// UDP with decimal/scientific delays, and digital/digital_delay_notation.v
// executes real module parameter overrides that do permit scale factors.
//! lrm 2.6.2
//! lrm 2.6.2:3
//! reject-only E0247
//! neighbour ../digital/digital_delay_notation.v
//! neighbour ../digital/digital_delay_primitive_notation.v
`include "disciplines.vams"
module digital_scaled_udp_delay_rejected(p);
  inout p;
  electrical p;
  wire q;
  scaled_delay_buffer #(0 ? 2u : 0.25) g(q, 1'b0);
  analog I(p) <+ 1m;
endmodule
primitive scaled_delay_buffer(q, a);
  output q;
  input a;
  table
    0 : 0;
    1 : 1;
  endtable
endprimitive
