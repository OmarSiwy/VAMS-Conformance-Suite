// Host-profile input for AMS 2.9.2:1001, 2.9.2:1002 and 3.4.7:5.
// Instantiate with m=4, resistance_alias=2000 and V(p,n)=1.
// Short report: omit hidden; show resistance, never resistance_alias.
// All operating-point reports: multiplied=12, divided=2, unchanged=5.
// The internal values remain 3, 8 and 5. A host report must apply scaling;
// substituting internal-value checks would not test this requirement.
// tests/host.py makes the exact host assertions.
// Every value also participates in the current: at the specified bias,
// I(p,n) = 4 * (1/2000) * (1+1+1+1)/4 = 0.002 A.
// Applying reporting multiplicity to the actual variables changes this
// current and must fail the independent circuit-behavior observation.
`include "disciplines.vams"
module operating_point_report_attributes(p,n);
  inout p,n; electrical p,n;
  aliasparam m=$mfactor;
  (* op="yes" *) parameter real resistance=1000;
  aliasparam resistance_alias=resistance;
  (* op="no" *) real hidden;
  (* op="yes", multiplicity="multiply" *) real multiplied;
  (* op="yes", multiplicity="divide" *) real divided;
  (* op="yes", multiplicity="none" *) real unchanged;
  analog begin
    hidden=17;
    multiplied=3;
    divided=8;
    unchanged=5;
    I(p,n) <+ V(p,n)/resistance *
              (hidden/17 + multiplied/3 + divided/8 + unchanged/5)/4;
  end
endmodule
