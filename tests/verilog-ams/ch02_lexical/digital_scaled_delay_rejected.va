// AMS §2.6.2: "Scale factors are not allowed to be used in defining digital
// delays (e.g., #5u)." A discrete process in a mixed module obeys the same
// restriction as a standalone digital design. digital_delay_notation.va is
// the emitted mixed-host legal neighbour, with #2.5 and #5e3 in ns units.
//! lrm 2.6.2
//! lrm 2.6.2:3
//! reject-only E0247
//! neighbour digital_delay_notation.va
`include "disciplines.vams"
`timescale 1ns/1ps
module digital_scaled_delay_rejected(p);
  inout p;
  electrical p;
  reg q;
  initial begin q = 0; #5u q = 1; end
  analog I(p) <+ q * 1m;
endmodule
