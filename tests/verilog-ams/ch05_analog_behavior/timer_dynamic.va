// §5.10.3.3 a period changed at a scheduled event. The host changes V(ctl)
// and rejects a trial step; both the schedule and the count must revert.
`include "disciplines.vams"
module timer_dynamic(out, ctl);
  inout out, ctl;
  electrical out, ctl;
  parameter real start = 0;
  parameter real period = 2n;
  real per;
  integer fires;
  analog begin
    per = V(ctl) > 0.5 ? 2 * period : period;
    @(timer(start, per)) fires = fires + 1;
    I(out) <+ fires;
    I(ctl) <+ 0;
  end
endmodule
