// The controlling branch uses loose voltage tolerance, but the equality's
// left-hand access is a tight voltage. Its equation must use the latter.
// Host scenario for AMS 5.6.7:1002. A solver-observation test must inspect
// the equality residual's convergence tolerance, which must be 1e-9.
// u_abstol describes the CURRENT UNKNOWN and is not an oracle for this
// voltage EQUATION. tests/host.py observes
// the real solver row and its gate on either side of the 1 nV boundary.
// The support model alone earns no test credit. The solved resistor chain
// has V(sense)=1 V, V(drive)=2 V and I(control)=-1 mA.
`include "disciplines.vams"
nature tight_voltage : Voltage;
  abstol=1n;
endnature
discipline tight_electrical;
  potential tight_voltage; flow Current;
enddiscipline
module indirect_equation_lhs_tolerance;
  electrical drive;
  tight_electrical sense;
  branch (drive) control;
  analog begin
    I(drive,sense) <+ V(drive,sense)/1000;
    I(sense) <+ V(sense)/1000;
    V(control) : V(sense) == 1.0;
  end
endmodule
