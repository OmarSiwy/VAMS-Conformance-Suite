// §5.10, after Syntax 5-13: "Analog events can also be detected within digital
// blocks. ... The usage of initial_step and final_step analog events are not
// allowed in the digital context."
//
// An `always` block is the digital context (§7.2.2), and `@(initial_step)` is the
// §5.10.2 global event the sentence names. The legal neighbour is a digital
// `always` whose event control is a monitored analog event,
// ../ch07_mixed_signal/event_bounds_mixed_legal.va (`always @(cross(...))`,
// §7.3.5), which must keep compiling: what is refused is this event in that
// context, not analog events in digital blocks.
//
// The refusal must be this rule's: the source is ILLEGAL. VerA refuses it,
// but with E0437, whose title is "this discrete process needs a mixed-signal
// kernel feature VerA does not implement" and whose explanation says "The
// source is legal Verilog-AMS"; its message calls the event "§7.3.6.1's A2D
// event". That is the wrong verdict for the right outcome, and pinning it
// would launder the gap into a pass, so the pin is the clause's phrase.
//
//! lrm 5.10
//! lrm 5.10:3
//! reject-only digital context
//! neighbour cross_expr_tol_and_time_tol_both_hold.va
`include "disciplines.vams"
`timescale 1ns/1ps
module b3_initial_step_in_digital_context(p);
  inout p; electrical p;
  real r;
  always @(initial_step) r = 1.0;              // illegal: §5.10.2 event, digital context
  analog I(p) <+ 0.0;
endmodule
