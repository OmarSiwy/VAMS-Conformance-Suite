// §5.10.3.4, under Syntax 5-19: "absdelta ( expr , delta [ , time_tol [ ,
// expr_tol [ , enable ] ] ] ) where expr and delta are required; time_tol,
// expr_tol and enable are optional arguments." The syntax agrees: both of the
// first two slots are `analog_expression`, with no optional bracket.
//
// `absdelta(V(p))` omits delta, the change in expr that generates an event,
// so the function has no criterion to sample on. It sits in an `always`
// block, the only place §5.10.3.4 allows absdelta(), so the placement rule
// (E0513, absdelta_digital_only.va) is not what is under test.
// ../ch07_mixed_signal/event_bounds_mixed_legal.va calls absdelta() from
// `always` blocks with both required arguments and must keep compiling.
//
// The expected refusal is the §5.10.3 event-argument code, E0517.
//
//! lrm 5.10.3.4
//! lrm 5.10.3.4:1
//! reject-only E0517
//! neighbour absdelta_samples_analog_changes.va
`include "disciplines.vams"
`timescale 1ns/1ps
module b3_absdelta_without_delta(p);
  inout p; electrical p;
  real sampled;
  always @(absdelta(V(p))) sampled = V(p);      // illegal: delta is required
  analog I(p) <+ 0.0;
endmodule
