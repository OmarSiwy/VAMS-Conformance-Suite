// A.6.4 lists `event_trigger` under `analog_event_statement` and not under
// `analog_statement`, so `-> ev;` written directly on the analog spine has no
// derivation. §5.10.4: named events "can be triggered from always and initial
// blocks, or from an analog event statement"; the analog spine is none of
// those. The legal neighbour performs the same trigger from an analog event
// statement (`@(timer(...)) -> tick;`).
//
//! lrm A.6.4
//! lrm A.6.5
//! lrm 5.10.4
//! lrm 5.10.4:1001
//! reject-only E0434
//! neighbour named_event_unsupported.va
`include "disciplines.vams"
module ch5_bare_trigger(p, n);
  inout p, n;
  electrical p, n;
  event ev;
  analog begin
    -> ev;
    I(p, n) <+ V(p, n);
  end
endmodule
