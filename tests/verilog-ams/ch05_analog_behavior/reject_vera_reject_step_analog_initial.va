// VerA's `$vera_reject_step` in an `analog initial` block.
//
// The request is read off the solution a transient step is accepting
// (`updateState`). §5.2.1's `analog initial` block runs once per analysis,
// before any step exists, so there is nothing for it to reject. E0533 names
// it. The legal neighbour, the task in an analog block, is
// vera_reject_step_retry.va.
//! lrm 2.8.3
//! reject-only E0533
//! neighbour ../../verilog-a/ch05_analog_behavior/vera_reject_step_retry.va
`include "disciplines.vams"
module reject_vera_reject_step_analog_initial(p, n);
  inout p, n; electrical p, n;
  analog initial $vera_reject_step(0.5);
  analog I(p, n) <+ V(p, n) / 1k;
endmodule
