// AMS §7.3.1 maps the two-bit reg to a zero-extended analog integer. Writing
// seven leaves the low two bits, so its analog value is three, not seven.
// At the second timer event, rate changes from two to three. §5.10.3.3 uses
// that final control for the next deadline: period*rate/2 changes from 2 ns
// to 3 ns. tests/fixtures/ch05_analog_behavior/timer_host.zig checks the emitted breakpoint, event count,
// body count, and a rejected trial followed by a retry.
`include "disciplines.vams"
module timer_body_reg_controls(out, body);
  inout out, body;
  electrical out, body;
  parameter real period = 2n;
  reg [1:0] rate;
  integer fires, executions;
  analog begin
    @(initial_step) rate = 2;
    @(timer(0, period * rate / 2.0)) begin
      fires = fires + 1;
      executions = executions + 1;
      if (fires == 2) rate = 7;
    end
    I(out) <+ fires;
    I(body) <+ executions;
  end
endmodule
