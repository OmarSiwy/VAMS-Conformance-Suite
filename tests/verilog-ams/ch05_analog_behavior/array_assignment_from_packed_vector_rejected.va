// §5.7: "Verilog-AMS supports both packed arrays and unpacked arrays of data.
// The term packed array is used to refer to the dimensions declared before the
// data identifier name. The term unpacked array is used to refer to the
// dimensions declared after the data identifier name." and then "The arrays on
// the LHS and the RHS of the assignment must be unpacked."
//
// `reg [1:0] B` declares its dimension before the name: B is the clause's
// packed array (its `wire [7:0] c1` example, as a reg). A is unpacked, with
// the same two elements. So `A = B` has an unpacked target and a packed
// source, and the sentence forbids it. array_assignment_compatible.va is
// the same assignment with B declared `integer B[0:1]`, unpacked, and must
// keep compiling: the pair differs only in where B's dimension is written.
//
// B is given its value by a constant `initial` (§7.2.2 makes it discrete-owned
// and the analog block reads it through Table 7-1), which keeps the module a
// non-mixed one; that is incidental to the rule.
//
// The expected refusal is §5.7's array-compatibility diagnostic, E0429
// "incompatible array assignment".
//
//! lrm 5.7
//! lrm 5.7:5
//! reject-only E0429
//! neighbour ../../verilog-a/ch05_analog_behavior/array_assignment_compatible.va
`include "disciplines.vams"
module b3_array_assignment_from_packed_vector(p);
  inout p; electrical p;
  integer A[0:1];
  reg [1:0] B;
  initial B = 2'b01;
  analog begin
    A = B;                               // illegal: B is packed
    I(p) <+ 0.0;
  end
endmodule
