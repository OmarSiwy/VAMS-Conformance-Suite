// §5.10.3.3 final function evaluation keeps the timer's original module
// context (§9.15 module query), after another child's analog block lowered.
// The host follows 0,2,3,6 ns and retries the second event as in the scalar
// neighbor. The function must see timer_context_child both before and after
// the event body; the unrelated child contributes zero to the same port.
`include "disciplines.vams"
module timer_body_context_controls(out, body);
  inout out, body; electrical out, body;
  parameter real period = 2n;
  timer_context_child #(.period(period)) u(out, body);
  timer_other_child v(out);
endmodule
module timer_context_child(out, body);
  inout out, body; electrical out, body;
  parameter real period = 2n;
  analog function real scaled;
    input rate; real rate;
    begin scaled = ($simparam$str("module") == "timer_context_child") ? rate : 2*rate; end
  endfunction
  real rate;
  integer fires, executions;
  analog begin
    @(initial_step) rate = 1;
    @(timer(0, period * scaled(rate))) begin
      fires = fires + 1;
      executions = executions + 1;
      if (fires == 2) rate = 1.5;
    end
    I(out) <+ fires;
    I(body) <+ executions;
  end
endmodule
module timer_other_child(p);
  inout p; electrical p;
  analog I(p) <+ 0;
endmodule
