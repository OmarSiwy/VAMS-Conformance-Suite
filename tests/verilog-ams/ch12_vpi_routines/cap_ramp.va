// The design reactive_branch_flow.c runs (VAMS-2023 12.10, 5.4.1,
// 5.6.1.2): three capacitors, c0 alone across one ideal ramp, c1 and c2 in
// parallel across another, so a VPI flow read takes a reactive half from a
// row of its own (c0) and from each instance's share of a row two instances
// share (c1, c2).
//
//     V(a, gnd) = V(b, gnd) = 1000 * $abstime     (ideal sources)
//     I(p, n) <+ c * ddt(V(p, n))                 (each capacitor)
//
// Each capacitor's own branch carries c * dV/dt = c * 1000 at every t > 0:
// 1e-3 A for c0 and c1 (1 uF), 3e-3 A for c2 (3 uF). The (b, gnd) row is the
// sum, 4e-3 A.
//
// No `//!` directive, so the suite does not collect it (tests/suite.zig
// `fixtureExt`): every number is asserted from C.
`include "disciplines.vams"
module p03_cr_ramp(p, n);
    inout p, n;
    electrical p, n;
    parameter real slope = 1000.0;
    analog
        V(p, n) <+ slope * $abstime;
endmodule

module p03_cr_cap(p, n);
    inout p, n;
    electrical p, n;
    parameter real c = 1e-6 from (0:inf);
    analog
        I(p, n) <+ c * ddt(V(p, n));
endmodule

module p03_cap_ramp;
    electrical a, b, gnd;
    ground gnd;
    p03_cr_ramp #(.slope(1000.0)) va(.p(a), .n(gnd));
    p03_cr_ramp #(.slope(1000.0)) vb(.p(b), .n(gnd));
    p03_cr_cap  #(.c(1e-6))       c0(.p(a), .n(gnd));
    p03_cr_cap  #(.c(1e-6))       c1(.p(b), .n(gnd));
    p03_cr_cap  #(.c(3e-6))       c2(.p(b), .n(gnd));
endmodule
