// The design task_output_jacobian.c runs (VAMS-2023 12.22.2, 12.32.2):
// one user-defined analog system TASK, $p03_cube(icube, V(q, gnd)), whose
// calltf writes its first argument and the partial of that argument with
// respect to the second, and a node the solver must FIND, not one a `//!
// bias` pins.
//
//     I(q, gnd) <+ icube - 7.0,   icube = (V + 1)^3 - 1
//
// KCL at q: (V + 1)^3 - 1 - 7 = 0, so (V + 1)^3 = 8 and V(q, gnd) = 1 exactly,
// where d(icube)/dV = 3 * (1 + 1)^2 = 12. Newton from the cold start V = 0
// (u = V + 1 = 1) runs u = 1, 3.333, 2.462, 2.081, 2.0031, 2.0000073, 2,
// each step needing the partial the application put: with that Jacobian entry
// dropped the q column has no pivot, V holds 0, and the residual stays -7.
//
// No `//!` directive, so the suite does not collect it (tests/suite.zig
// `fixtureExt`): without an application nothing defines $p03_cube, and what
// an unregistered call leaves in icube is no clause's. Every number is
// asserted from C.
`include "disciplines.vams"
module p03_cube_solve;
    electrical q, gnd;
    ground gnd;
    real icube;
    analog begin
        $p03_cube(icube, V(q, gnd));
        I(q, gnd) <+ icube - 7.0;
    end
endmodule
