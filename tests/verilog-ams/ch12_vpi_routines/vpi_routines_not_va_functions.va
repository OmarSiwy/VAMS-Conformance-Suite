// §4.7: an analog function call names an analog user-defined function or a
// built-in; `vpi_*` are Clause 12's C routines, called by a VPI application
// through the PLI, and none of them is either (a `$`-less identifier with no
// declaration is an unknown function). So each call below is refused, E0512,
// and each name is pinned by its own `//! reject` substring so one refusal
// cannot stand in for thirty-five.
//
// This does not exercise the VPI contract: Clause 12's behaviour is the `.c`
// fixtures'. It pins only that the routine names do not leak into Verilog-A.
//
//! lrm 4.7
//! reject-only E0512
//! reject `vpi_chk_error`
//! reject `vpi_compare_objects`
//! reject `vpi_free_object`
//! reject `vpi_get`
//! reject `vpi_get_cb_info`
//! reject `vpi_get_analog_delta`
//! reject `vpi_get_analog_freq`
//! reject `vpi_get_analog_time`
//! reject `vpi_get_analog_value`
//! reject `vpi_get_delays`
//! reject `vpi_get_str`
//! reject `vpi_get_analog_systf_info`
//! reject `vpi_get_systf_info`
//! reject `vpi_get_time`
//! reject `vpi_get_value`
//! reject `vpi_get_vlog_info`
//! reject `vpi_get_real`
//! reject `vpi_handle`
//! reject `vpi_handle_by_index`
//! reject `vpi_handle_by_name`
//! reject `vpi_handle_multi`
//! reject `vpi_iterate`
//! reject `vpi_mcd_close`
//! reject `vpi_mcd_name`
//! reject `vpi_mcd_open`
//! reject `vpi_mcd_printf`
//! reject `vpi_printf`
//! reject `vpi_put_delays`
//! reject `vpi_put_value`
//! reject `vpi_register_cb`
//! reject `vpi_register_analog_systf`
//! reject `vpi_register_systf`
//! reject `vpi_remove_cb`
//! reject `vpi_scan`
//! reject `vpi_sim_control`
`include "disciplines.vams"
module ch12_vpi_routines_not_va(p, n);
  inout p, n; electrical p, n;
  analog begin
    I(p,n) <+ vpi_chk_error(0);
    I(p,n) <+ vpi_compare_objects(0);
    I(p,n) <+ vpi_free_object(0);
    I(p,n) <+ vpi_get(0);
    I(p,n) <+ vpi_get_cb_info(0);
    I(p,n) <+ vpi_get_analog_delta(0);
    I(p,n) <+ vpi_get_analog_freq(0);
    I(p,n) <+ vpi_get_analog_time(0);
    I(p,n) <+ vpi_get_analog_value(0);
    I(p,n) <+ vpi_get_delays(0);
    I(p,n) <+ vpi_get_str(0);
    I(p,n) <+ vpi_get_analog_systf_info(0);
    I(p,n) <+ vpi_get_systf_info(0);
    I(p,n) <+ vpi_get_time(0);
    I(p,n) <+ vpi_get_value(0);
    I(p,n) <+ vpi_get_vlog_info(0);
    I(p,n) <+ vpi_get_real(0);
    I(p,n) <+ vpi_handle(0);
    I(p,n) <+ vpi_handle_by_index(0);
    I(p,n) <+ vpi_handle_by_name(0);
    I(p,n) <+ vpi_handle_multi(0);
    I(p,n) <+ vpi_iterate(0);
    I(p,n) <+ vpi_mcd_close(0);
    I(p,n) <+ vpi_mcd_name(0);
    I(p,n) <+ vpi_mcd_open(0);
    I(p,n) <+ vpi_mcd_printf(0);
    I(p,n) <+ vpi_printf(0);
    I(p,n) <+ vpi_put_delays(0);
    I(p,n) <+ vpi_put_value(0);
    I(p,n) <+ vpi_register_cb(0);
    I(p,n) <+ vpi_register_analog_systf(0);
    I(p,n) <+ vpi_register_systf(0);
    I(p,n) <+ vpi_remove_cb(0);
    I(p,n) <+ vpi_scan(0);
    I(p,n) <+ vpi_sim_control(0);
  end
endmodule
