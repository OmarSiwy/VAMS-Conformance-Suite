// The design functype.c runs (VAMS-2023 12.32.1 sysfunctype): two
// user-defined analog system FUNCTIONS of one argument, $b7_ifn registered
// vpiIntFunc and $b7_rfn registered vpiRealFunc, each called from ONE site
// (two_sites.va holds the two-site case), divided by the integer 2. The
// argument is $abstime; the value each calltf puts does not depend on it.
//
// No `//!` directive, so the suite does not collect it (tests/suite.zig
// `fixtureExt`): without an application nothing defines either function, and
// what an unregistered call yields is no clause's (01_analog_systf_resistor
// _call.va gives the reason). Every number is asserted from C, which knows
// what each calltf put.
//
// Two ideal sources, (a, gnd) and (b, gnd), carry the two values to
// quantities the application reads through §12.10.
`include "disciplines.vams"
module b7_functype;
    electrical a, b, gnd;
    ground gnd;
    real ha, hb;
    analog begin
        ha = $b7_ifn($abstime) / 2;
        hb = $b7_rfn($abstime) / 2;
        V(a, gnd) <+ ha;
        V(b, gnd) <+ hb;
    end
endmodule
