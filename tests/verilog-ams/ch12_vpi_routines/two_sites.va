// The design calltf_sites.c runs (VAMS-2023 12.32.1 calltf): one
// user-defined analog system FUNCTION, $b7_cfn, invoked from two call sites,
// each value contributed to its own node.
//
// No `//!` directive, so the suite does not collect it (tests/suite.zig
// `fixtureExt`): without an application nothing defines the function, and
// what an unregistered call yields is no clause's. Every number is asserted
// from C, which knows what its calltf put. (48_systf_name_repeated_call_sites
// .va is the compiler's half: one name, several call sites, is legal source.)
`include "disciplines.vams"
module b7_two_sites;
    electrical a, b, gnd;
    ground gnd;
    real v1, v2;
    analog begin
        v1 = $b7_cfn(1.0);
        v2 = $b7_cfn(2.0);
        V(a, gnd) <+ v1;
        V(b, gnd) <+ v2;
    end
endmodule
