// §10.2, the sentence with teeth: "In addition to `resetall, if this directive
// is used without a discipline name, discipline resolution will not use a
// default discipline for nets declared after this directive is encountered in
// the text stream."
//
// The bare directive withdraws the sole discipline available to these ports.
// Neither port has an explicit declaration or a connected typed child, so
// V(p,n) and I(p,n) cannot resolve through a nature (§7.4 and §3.6.1).
// E0337 is the named refusal for accessing a net without a discipline.
//
// default_discipline_undeclared_net.va retains the default on the same port
// shape and observes V(p,n) = 0.75 - 0.25 = 0.5. The host assertion
// test_bare_default_discipline_withdraws_the_default requires both that legal
// value and this E0337-only refusal before awarding §10.2:1001 positive
// behavioral evidence. A bare rejection by itself does not prove the pair.
//
//! lrm 10.2
//! lrm 7.4
//! lrm 3.6.1
//! lrm 10.2:1000
//! reject-only E0337
//! neighbour default_discipline_undeclared_net.va
`include "disciplines.vams"
`default_discipline electrical
`default_discipline
module ch10_default_discipline_reset_leaves_no_default(p, n);
  inout p, n;
  analog I(p, n) <+ V(p, n);
endmodule
