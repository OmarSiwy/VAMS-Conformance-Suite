// IEEE Std 1364 §19.2, which §10.1 Table 10-1 carries over unchanged, closes
// the operand slot over eleven words:
//
//     default_nettype_value ::= wire | tri | tri0 | tri1 | wand | triand
//                             | wor | trior | trireg | uwire | none
//
// No brackets, so the operand is mandatory, and a closed alternation, so a word
// off the list is a syntax error and not a twelfth net type.
//
// THE OPERAND BELOW IS DELIBERATE AND IT IS `reg`. §10.2's own Syntax 10-1
// closes a DIFFERENT slot over a DIFFERENT fifteen words, and `reg` is on that
// list — `` `default_discipline ddiscrete reg `` is legal Verilog-AMS, which 42
// compiles. The two directives look alike enough that writing one's operand
// after the other's name is the mistake worth catching, and a tool that shares
// one table between them accepts this file. (`integer`, `real`, `wreal`,
// `supply0` and `supply1` are the other four that are qualifiers but not net
// types; `uwire` and `none` run the other way.)
//
// Nothing else here is unusual: the module is 16's one-resistor body, so the
// only thing under test is the directive.
//
//! lrm 10.1
//! reject-only E0140
`include "disciplines.vams"
`default_nettype reg
module ch10_default_nettype_value_grammar(p, n);
    inout p, n;
    electrical p, n;
    analog I(p, n) <+ V(p, n);
endmodule
