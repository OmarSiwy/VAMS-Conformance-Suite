// A directive's operands are grammar, not free text after the accent grave.
//
//   Syntax 10-1:  `default_discipline [ discipline_identifier [ qualifier ] ]
//                 qualifier ::= integer | real | reg | wreal | wire | tri
//                             | wand | triand | wor | trior | trireg | tri0
//                             | tri1 | supply0 | supply1
//
// A closed alternation of fifteen names. `electrical` is a discipline, not a
// qualifier, so `default_discipline electrical electrical is a syntax error —
// and it is exactly the typo the rule exists to catch, because the two
// operands are adjacent identifiers and duplicating or swapping one reads as
// plausible source. 02 and 42 use the qualifier form correctly, so nothing in
// the chapter noticed a front end that accepted any word in that slot.
//
// One rule per file. This fixture and 48 (Syntax 10-2's mandatory operand)
// were a single file until a review pointed out the merge was backwards: the
// runner requires EVERY `//! reject` substring to appear somewhere in the
// diagnostics of ONE compile, so a front end that stops at the first bad
// directive — the normal thing for a preprocessor to do — diagnosed both rules
// correctly and still FAILed. Two independent rules in two clauses need two
// compiles.
//
// Two pins. The substring "qualifier" is the term Syntax 10-1 itself uses and
// does not occur in the directive being diagnosed, so it says which rule fired
// in words any tool could print. E0127 is VerA's code for that same rule, and
// codes are never renumbered (lib/diag_code.zig's RULES), so pinning it too
// costs nothing and stops a different diagnostic that happens to say
// "qualifier" from satisfying the file.
//
//! lrm 10.2
//! reject-only qualifier
//! reject E0127
`include "disciplines.vams"
`default_discipline electrical electrical
module ch10_default_discipline_qualifier_grammar(p, n);
  inout p, n; electrical p, n;
  analog I(p, n) <+ V(p, n);
endmodule
