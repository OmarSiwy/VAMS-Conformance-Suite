// §6.6.1: "It shall be an error if any bit of the genvar is set to x or z."
//
// The initialization assigns the genvar `1'bx`. 1'bx is a constant expression
// (§2.6 / IEEE 1364-2005 3.5.1: x is a legal digit of a sized constant), so
// A.4.2's `genvar_initialization ::= genvar_identifier = constant_expression`
// admits it and only this rule refuses it. The neighbour
// genvar_starts_at_zero.va differs only in that value, 0.
//
//! lrm 6.6.1
//! lrm 6.6.1:8
//! reject-only genvar
//! neighbour ../../verilog-a/ch06_hierarchy/genvar_starts_at_zero.va
`include "disciplines.vams"
module b4_gsx(p);
  inout p; electrical p;
  genvar i;
  integer n;
  analog n = 0;
  generate
    for (i = 1'bx; i < 1; i = i + 1) begin : g
      analog n = n + 1;
    end
  endgenerate
  analog I(p) <+ V(p);
endmodule
