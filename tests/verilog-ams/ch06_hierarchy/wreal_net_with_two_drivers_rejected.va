// §6.5.3 Real valued ports:
//
//   "Ports may be declared as real-valued with a discrete-time discipline using
//    the net type wreal (defined in 3.7). THERE CAN BE A MAXIMUM OF ONE DRIVER
//    OF A REAL-VALUED NET."
//
// There is no resolution function to fall back on: IEEE 1364 resolves two
// drivers of a `wire` with the four-state conflict table, but two real values —
// 0.625 and 0.25 below — have no resolved value, no `x` to collapse to and no
// strength to order them. So a second driver is an error at elaboration, not a
// value at run time.
//
// `real_valued_wreal_port.va` is this design with ONE continuous assignment to
// `stim`: it runs and asserts that the child's wreal port delivers 0.625. Here
// the parent adds a second `assign` to the same net. The digital runner already
// refuses the pure-digital form (`digital/reject_wreal_two_drivers.v`,
// E0918); this is the mixed `.va` form, which used to compile to a device and
// fail only when its digital half first ran.
//
// EXACTLY ONE RULE IS BROKEN: delete either `assign` and the design is the
// legal one.
//
//! lrm 6.5.3
//! lrm 6.5.3:1001
//! lrm 3.7
//! reject-only E0918
//! reject `stim` is already driven
//! neighbour real_valued_wreal_port.va
`include "disciplines.vams"
module ch6_wreal_two_drivers(out);
  output out;
  voltage out;
  wreal stim;
  assign stim = 0.625;
  assign stim = 0.25;
  ch6_wreal_two_drivers_drv f1(stim, out);
endmodule

module ch6_wreal_two_drivers_drv(in, out);
  input in;
  output out;
  wreal in;
  voltage out;
  analog V(out) <+ in;
endmodule
