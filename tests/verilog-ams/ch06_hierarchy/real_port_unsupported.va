// THIS REJECTION IS CORRECT CONFORMANCE, and the clause it pins is Syntax 6-7, not
// the annex this file used to cite. §6.5.2.2 gives the port direction declaration as
//
//     input [ discipline_identifier ] [ net_type | wreal ] [ signed ] [ range ]
//           list_of_port_identifiers
//
// and `real` is neither a `net_type` (A.2.2.1: supply0 … wor) nor `wreal`. So
// `input real x;` has no production in FULL Verilog-AMS either, with or without
// Annex C, and every compiler this suite is meant to run against diagnoses it.
//
// THE CITES USED TO BE C.8 AND 6.5.3 AND NEITHER WAS REACHABLE FROM THIS SOURCE.
// Annex C.8 excludes "support for real value ports" from Verilog-A, and §6.5.3
// defines what a real-valued port IS — "This is done using the net type wreal" —
// so pinning either one needs the source to write `input wreal x;`. This file never
// did. Nor can it simply be changed to: `input wreal x;` is LEGAL Verilog-AMS, so a
// fixture demanding its rejection would be inverted for every AMS compiler and
// right only for the Verilog-A subset. §6.5.3 and C.8 are therefore left uncovered
// by this chapter rather than credited to a file that cannot reach them.
//
// The road to the verdict is a parse boundary, which is worth writing down rather
// than hiding: VerA's port direction declaration takes an identifier or a
// discipline, so the keyword `real` is E0208 ("expected an identifier: found
// `real`"). It is the same code a ranged direction declaration gets in
// vector_ports.va — the parser has one shape for this position and everything else
// stops there.
//
//! lrm 6.5.2.2
//! reject-only E0208
`include "disciplines.vams"
module ch6_real_port(x);
  input real x;
  electrical p;
  analog I(p) <+ x;
endmodule
