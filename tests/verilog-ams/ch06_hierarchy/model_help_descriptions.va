// Host-profile input for AMS 6.2:10 and 6.4:5.
// Help for help_base must include "Base resistor help".
// Help for help_model must include "Paramset resistor help".
// Testing metadata emission alone would not test the user-facing help.
// tests/host.py requests the two help pages separately;
// a combined catalog containing both descriptions is not the observation.
`include "disciplines.vams"
(* desc="Base resistor help" *)
module help_base(p,n);
  inout p,n; electrical p,n;
  parameter real resistance=1000;
  analog I(p,n) <+ V(p,n)/resistance;
endmodule
(* desc="Paramset resistor help" *)
paramset help_model help_base;
  parameter real nominal_resistance=2000;
  .resistance=nominal_resistance;
endparamset
