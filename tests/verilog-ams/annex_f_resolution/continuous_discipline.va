// §3.6.2.2 + §3.6.3: a user-declared discipline that binds both natures and
// declares `domain continuous` is the discipline of a conservative analog net
// ("A net used for modeling a conservative system shall have a discipline with
// both access functions (potential and flow) defined"), and those access
// functions are the ones the NATURES name — `access = V` for the potential,
// `access = I` for the flow. So `V(p)` is the potential of p against ground,
// which the testbench holds at 0.7; the want is the bias, not anything VerA
// computed.
//
// NOT an Annex F fixture despite living here: Annex F resolves the discipline
// of UNDECLARED interconnect across a hierarchy. Here p carries an explicit
// discipline in its own module, so no Annex F sentence is reached — the cites
// name the clauses this source actually pins.
//
// The read-back is bit-exact, not approximate: `//! bias` stores 0.7 into the
// unknown vector and `V(p)` loads that same double back, so the difference is
// exactly 0.0 and `CHECKX` is the honest macro. There is no derived tolerance
// because there is no derived quantity — the value is the one supplied.
//
//! lrm 3.6.2.2
//! lrm 3.6.3
//! lrm 3.6.3:1
//! bias V(p) = 0.7
// Own base natures below: D.1's guard keeps annex D's out of check.vh's include.
`define DISCIPLINES_VAMS 1
`include "check.vh"
nature annex_f_voltage;
  units = "V";
  access = V;
  abstol = 1u;
endnature
nature annex_f_current;
  units = "A";
  access = I;
  abstol = 1p;
endnature
discipline annex_f_continuous;
  potential annex_f_voltage;
  flow annex_f_current;
  domain continuous;
enddiscipline
module annex_f_cont(p);
  inout p; annex_f_continuous p;
  analog begin
    `CHECKX("potential access function of the user-declared nature", V(p), 0.7);
    I(p) <+ V(p);
  end
endmodule
