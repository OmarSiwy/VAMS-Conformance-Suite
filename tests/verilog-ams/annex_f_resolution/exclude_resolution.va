// LRM §7.7.2, the `exclude` arm of the resolution connect statement (A.1.8
// discipline_identifier_or_exclude): "If the keyword exclude follows resolveto
// rather than a discipline identifier, then the otherwise compatible
// disciplines are deemed to be incompatible and an error is indicated if they
// are found on the same net." The clause's own example is two supply families
// — `connect logic18 logic32 resolveto exclude ;` — "these connect statements
// prevent ports associated with one supply voltage to be connected to nets
// associated with the other", and the two disciplines below are that example's
// continuous half with the supply spelled in the name.
//
// The rule is reached through Annex F.2.1 step 4.b (F.2.2 prints the same
// bullets, so both are cited): `sig` is undeclared, both child segments are
// continuous, so the candidate list is {annex_f_e18, annex_f_e33} — more than
// one — and that list matches the exclude statement's discipline list exactly.
// Without the statement this design is LEGAL and quietly so: the two
// disciplines are natureless and both `domain continuous`, so §3.11.1's
// Natureless Discipline Rule makes them compatible, no domain crossing exists,
// and step 4.b's fourth bullet ("the discipline is unknown. This is legal
// provided the net has no mixed-port connections") accepts the unknown. The
// exclude statement is therefore the ONLY rule this source trips — which is
// the point: §7.7.2 gives the designer a way to MAKE an otherwise-legal
// connection an error, and a compiler that parsed the statement and ignored
// it compiles this file clean.
//
// There is no value to CHECK: the only observable is the diagnostic. The
// reject line is a CODE, not a message fragment, per the suite contract —
// E0917 is the class-9 code for exactly this rule (lib/diag_code.zig), and a
// generic pattern could be satisfied by any unrelated refusal.
//
//! lrm 7.7.2
//! lrm F.2.1
//! lrm F.2.2
//! lrm 7.7.2:1000
//! reject-only E0917
//! neighbour resolveto_resolution.va
`include "disciplines.vams"
discipline annex_f_e18; domain continuous; enddiscipline
discipline annex_f_e33; domain continuous; enddiscipline
connectrules annex_f_supply_walls;
  connect annex_f_e18, annex_f_e33 resolveto exclude;
endconnectrules
module annex_f_e18_leaf(p);
  inout p; annex_f_e18 p;
endmodule
module annex_f_e33_leaf(p);
  inout p; annex_f_e33 p;
endmodule
module annex_f_excluded(sig);
  inout sig;
  annex_f_e18_leaf la(sig);
  annex_f_e33_leaf lb(sig);
endmodule
