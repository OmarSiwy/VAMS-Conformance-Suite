// E.3.1 Unsupported primitives: "Verilog-AMS HDL does not support the concept of
// passing an instance name as a parameter. As such, the following primitives are
// not supported: ccvs, cccs, and mutual inductors." A mutual inductor names the
// two inductor INSTANCES it couples, which is exactly the construct that
// sentence rules out. So unlike the rest of Annex E, a rejection here is what
// the LRM asks for.
//
// WHAT THE SOURCE HAS TO CONTAIN. E.3.1's objection is to the ARGUMENT, not the
// primitive: an instance name where a parameter or port expression belongs. A
// coupling written `mutual_inductor #(.k(0.9)) k1(l1, l2);` passes the names of
// two inductor INSTANCES, which is the forbidden thing; the same line written
// over two NETS would be an ordinary two-terminal instantiation and would
// demonstrate nothing E.3.1 rules out. `l1` and `l2` are therefore instance
// names and must stay free identifiers — declaring the two `inductor` instances
// they refer to would add a line E.2.2.3 prints as LEGAL, and since VerA refuses
// every instantiation the fixture would then reject on a conforming line instead
// of the offending one. Same reason `sense` is free in unsupported_cccs.va.
//
// THE NAME IS THIS SUITE'S, NOT THE LRM's. E.3.1 says "mutual inductors" in
// prose only. Table E.1 has no mutual-inductor row and no clause of Annex E
// gives the construct an identifier — `ccvs` and `cccs` are spelled out, this
// one is not. `mutual_inductor` and `k` below are our own spellings, so the
// rejection attaches to E.3.1 by the shape of the argument list rather than by
// name.
//
// HONEST CEILING, doubled here. VerA answers with E0904, "instance names no
// module" (§6.2.2), which is literally true — nothing declares
// `mutual_inductor`, here or in the prelude, because E.3.1 excludes it — and is
// also what `foo k1(a, b);` gets. What this fixture buys is that the coupling
// form never compiles; separating "refused as an E.3.1 primitive" from "refused
// as an undefined module" needs a dedicated diagnostic code. It used to pin
// E0204, "module instantiation is not supported", which was the flat-module limit
// and is now retired.
//
//! lrm E.3.1
//! lrm E.3.1:1000
//! reject-only E0904
`include "disciplines.vams"
module annex_e_unsupported_mutual_inductor(p, n);
  inout p, n; electrical p, n;
  // l1 and l2 are the names of two INDUCTOR INSTANCES — E.3.1's "passing an
  // instance name as a parameter", which Verilog-AMS has no syntax for.
  mutual_inductor #(.k(0.9)) k1(l1, l2);
endmodule
