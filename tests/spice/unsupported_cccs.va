// E.3.1 Unsupported primitives: "Verilog-AMS HDL does not support the concept of
// passing an instance name as a parameter. As such, the following primitives are
// not supported: ccvs, cccs, and mutual inductors". `cccs` is the current-
// controlled current source: its controlling argument is the NAME of a voltage
// source instance, not a net, and Verilog-AMS has no syntax for that argument.
// So unlike the rest of Annex E, a rejection here is what the LRM asks for.
//
// `sense` is therefore a free identifier, and must stay one: the construct that
// would give it a meaning is the one E.3.1 forbids. An earlier revision followed
// the cccs with `vsine #(.dc(0.0)) sense(.p(p), .n(n));` so the controlling name
// would refer to something — but that instantiation raises the SAME diagnostic,
// so the fixture rejected whether or not the cccs line was present at all. It is
// gone, and the reject is now attributable to the line the fixture names.
//
// HONEST CEILING. VerA answers with E0904, "instance names no module" (§6.2.2):
// `cccs` is not a module VerA has, and once Annex E's supported primitives ship
// as prelude modules it still will not be one, because E.3.1 excludes it. That is
// a better-attributed refusal than the E0204 this fixture used to pin — E0204 was
// "module instantiation is not supported", the flat-module limit, and it is now
// retired — but it is still not E.3.1's own rule: the same code answers a
// misspelled module name. Full discrimination needs a diagnostic dedicated to the
// E.3.1 primitives and is not this fixture's to buy; what it does buy is that the
// source below never compiles.
//
//! lrm E.3.1
//! lrm E.3.1:1000
//! reject-only E0904
//! neighbour cccs_inside_a_spice_subcircuit.va
`include "disciplines.vams"
module annex_e_unsupported_cccs(p, n);
  inout p, n; electrical p, n;
  // Third argument is a controlling INSTANCE name, which E.3.1 has no way to pass.
  cccs f1(p, n, sense, 2.0);
endmodule
