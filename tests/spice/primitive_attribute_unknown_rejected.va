// E.3.2.1 requires the string to identify a valid continuous discipline.
// This string names no declared discipline; it must not be silently ignored.
//! lrm E.3.2.1
//! lrm E.3.2.1:3
//! reject-only port_discipline names an undeclared discipline
//! neighbour primitive_discipline.va
`include "disciplines.vams"
module audit_e_bad_attribute_unknown(p,n);
  inout p,n; electrical p,n;
  (* port_discipline="audit_missing_discipline" *) resistor #(.r(1000.0)) r(p,n);
endmodule
