// E.1.2, second bullet: "Not all SPICE simulators support the same set of
// component primitives. Thus, a particular SPICE netlist can reference a
// primitive which is unsupported. Verilog-AMS HDL offers no alternative in
// this case other than the possibility that if the model equations are
// known, the primitive can be rewritten as a module."
// `SW` (the SPICE voltage-controlled switch) is no Table E.1 row, so the
// `.MODEL SW1 SW` card declares nothing VerA can instantiate. The instance
// of it is refused by that rule, E0952 naming the card's type, not as the
// unknown module (E0904) a misspelling gets.
// spice_supported_model_type_neighbour.va is the legal neighbour: the same
// card with a Table E.1 type compiles and runs.
//! lrm E.1.2
//! reject-only E0952
//! reject `sw1` is a SPICE `.MODEL` of type `sw`
//! neighbour spice_supported_model_type_neighbour.va
//! spice .MODEL SW1 SW RON=1 ROFF=1MEG VT=0.5
`include "disciplines.vams"
module spice_unsupported_model_type_rejected(p, n);
  inout p, n; electrical p, n;
  sw1 s1(p, n);
endmodule
