// §9.17.3 `$limit`'s seed argument whose value reads a probe only through
// the condition of a §4.2.12 `?:`.
//
// A seed is the value a branch starts at BEFORE the first Newton iterate
// (SPICE MODEINITJCT). It may read the card and what is computed from it, but
// no solution exists yet, so it may never read a probe or anything computed
// from one; E0527 names that (reject_limit_seed_reads_solution.va is the
// direct read). Here both arms, 0.6 and 0.0, are constants and the probe
// V(ai, c) sits in the condition alone: which constant the seed is still
// depends on the solution, so it is refused the same way (#78).
//
// The legal neighbour, limit_seed_conditional_on_card.va, is the same shape
// with a card parameter in the condition, and compiles.
//! lrm 9.17.3
//! reject-only E0527
//! neighbour limit_seed_conditional_on_card.va
`include "disciplines.vams"
module reject_limit_seed_reads_solution_through_conditional(a, c);
  inout a, c; electrical a, c, ai;
  real vd;
  analog begin
    vd = $limit(V(ai, c), "pnjlim", 0.025, 0.6, 1.0, (V(ai, c) > 0.3) ? 0.6 : 0.0);
    I(a, ai) <+ V(a, ai) / 10.0;
    I(ai, c) <+ 1e-14 * (limexp(vd / 0.025) - 1.0);
  end
endmodule
