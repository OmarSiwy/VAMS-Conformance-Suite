// E.4.2: "Some SPICE netlists provide mechanisms for mapping an instance to a
// group of models, with the final determination of which model to use being
// based on rules encapsulated in the SPICE netlist. Examples include model
// binning ... Support of SPICE model cards is implementation specific
// (including those using these mechanisms)." VerA reads SPICE's bins (VD-012):
// a card naming the group `NFET` takes the first `.MODEL NFET.N` with
// LMIN <= L < LMAX and WMIN <= W < WMAX. Here L = 3, which neither bin holds
// (0..0.5 and 0.5..2). SPICE stops on such a card; resolving it as the
// module `nfet`, or to the nearest bin, would put a model the netlist never
// chose in the circuit. It is refused at the card by name (E0928).
//
// Legal neighbour: spice_binned_model_selects_by_l_and_w.va, the same two
// bins with cards whose L each bin holds.
//
//! lrm E.4.2
//! lrm E.1.2
//! bias V(d) = 1.0, V(g) = 0.75, V(s) = 0.25, V(b) = 0.0
//! reject-only E0928
//! reject no bin of the binned model `nfet`
//! neighbour spice_binned_model_selects_by_l_and_w.va
//! spice .MODEL NFET.1 LINFET KP=1E-3 LMIN=0 LMAX=0.5
//! spice .MODEL NFET.2 LINFET KP=3E-3 LMIN=0.5 LMAX=2
//! spice .SUBCKT BINCELL D G S B
//! spice M1 D G S B NFET W=2 L=3
//! spice .ENDS BINCELL
`include "disciplines.vams"
module LinFet(d, g, s, b);
  inout d, g, s, b; electrical d, g, s, b;
  parameter real KP = 1e-3;
  parameter real W = 1.0;
  parameter real L = 1.0;
  analog I(d, s) <+ KP * (W / L) * V(g, s) * V(d, s);
endmodule

module annex_e_reject_binned_model(d, g, s, b);
  inout d, g, s, b; electrical d, g, s, b;
  bincell x1(d, g, s, b);
endmodule
