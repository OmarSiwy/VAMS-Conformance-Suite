// E.3.1 Unsupported primitives: "Verilog-AMS HDL does not support the concept of
// passing an instance name as a parameter. As such, the following primitives are
// not supported: ccvs, cccs, and mutual inductors". `ccvs` is the current-
// controlled voltage source: its controlling argument is the NAME of a voltage
// source instance, not a net, and Verilog-AMS has no syntax for that argument.
// So unlike the rest of Annex E, a rejection here is what the LRM asks for.
//
// `sense` is a free identifier, and must stay one: the construct that would give
// it a meaning is the one E.3.1 forbids. An earlier revision followed the ccvs
// with `vsine #(.dc(0.0)) sense(.p(p), .n(n));` so the controlling name would
// refer to something — but that instantiation raises the SAME diagnostic, so the
// fixture rejected whether or not the ccvs line was present. It is gone, and the
// reject is now attributable to the line the fixture names.
//
// HONEST CEILING. VerA answers with E0904, "instance names no module" (§6.2.2):
// `ccvs` is not a module VerA has, and once Annex E's supported primitives ship as
// prelude modules it still will not be one, because E.3.1 excludes it. That is
// better attributed than the E0204 this fixture used to pin — the flat-module
// limit, now retired — but it is still not E.3.1's own rule, since the same code
// answers a misspelled module name. Full discrimination needs a diagnostic
// dedicated to the E.3.1 primitives and is not this fixture's to buy.
//
//! lrm E.3.1
//! lrm E.3.1:1000
//! reject-only E0904
//! neighbour vcvs_inside_a_spice_subcircuit.va
`include "disciplines.vams"
module annex_e_unsupported_ccvs(p, n);
  inout p, n; electrical p, n;
  // Third argument is a controlling INSTANCE name, which E.3.1 has no way to pass.
  ccvs h1(p, n, sense, 2.0);
endmodule
