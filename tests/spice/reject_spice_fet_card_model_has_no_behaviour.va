// E.2: "while the Verilog-AMS HDL built-in primitives are standardized, the
// SPICE primitives are not. All aspects of SPICE primitives are implementation
// dependent", and Table E.1 leaves the Behavior column of the mosfet row empty.
// So a `.MODEL NCH NMOS LEVEL=72` (HSPICE's BSIM-CMG level) names a primitive
// VerA has no equations for. An M card bound to it inside a `.SUBCKT` would be
// a transistor that conducts nothing, an open where the netlist has a device:
// the silent wrong circuit VerA forbids. It is refused at the card,
// E0953, with E.1.2's remedy in the explanation (write the model as a module,
// and name it as the `.MODEL`'s type).
//
// HSPICE's `LEVEL = 72`, with spaces around the `=`, is read as one
// parameter; the refusal is about the type, not the spelling.
//
// Legal neighbour: spice_fet_card_instantiates_model_module.va, the same M card
// shape whose `.MODEL` type is a Verilog-A module (`LINFET`); it compiles and
// conducts 0.018 A.
//
//! lrm E.2
//! lrm E.3
//! lrm E.1.2
//! bias V(d) = 1.0, V(g) = 0.75, V(s) = 0.25, V(b) = 0.0
//! reject-only E0953
//! reject Table E.1's `mosfet`
//! neighbour spice_fet_card_instantiates_model_module.va
//! spice .MODEL NCH NMOS LEVEL = 72
//! spice .SUBCKT CELL D G S B
//! spice M1 D G S B NCH W=1U L=20N
//! spice .ENDS CELL
`include "disciplines.vams"
module annex_e_reject_fet_without_behaviour(d, g, s, b);
  inout d, g, s, b; electrical d, g, s, b;
  cell x1(d, g, s, b);
endmodule
