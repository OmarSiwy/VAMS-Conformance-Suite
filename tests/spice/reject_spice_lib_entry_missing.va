// E.4.2 lets a netlist map an instance to "a group of models" through "corners
// support", and a `.LIB "file" entry` card is how a PDK names its corner: the
// lines between `.LIB entry` and `.ENDL` of that file. spice_lib_models.lib has
// entries FF and TT and no SS. Reading nothing for SS would leave every model
// of the corner undefined (or, worse, keep a stale one), so the card is refused
// by name (E0928, "has no `.lib ss` entry").
//
// Legal neighbour: spice_lib_include_hdl.va, the same card naming TT, which
// compiles and conducts 0.006 A.
//
//! lrm E.4.2
//! lrm E.1.2
//! bias V(d) = 1.0, V(g) = 0.75, V(s) = 0.25, V(b) = 0.0
//! reject-only E0928
//! reject has no `.lib SS` entry
//! neighbour spice_lib_include_hdl.va
//! spice .LIB "spice_lib_models.lib" SS
//! spice .INCLUDE "spice_lib_cell.inc"
`include "disciplines.vams"
module annex_e_reject_lib_entry_missing(d, g, s, b);
  inout d, g, s, b; electrical d, g, s, b;
  cell x1(d, g, s, b);
endmodule
