// H04, the one REJECT in this set — Table E.1 fixes the parameter names of a
// SPICE primitive, and §6.3.3 forbids naming one that is not there.
//
// WHAT THIS FILE USED TO CLAIM, AND WHY THAT CLAIM IS GONE.
// ---------------------------------------------------------------------------
// The previous `11_reject_unmapped_model_card_parameter.va` asserted that a
// model card carrying a parameter Table E.1 does not declare —
// `.MODEL RBAD R RSH=50` — must be DIAGNOSED by the netlist reader. That claim
// was invented. E.1.2's third bullet, its only support, reads:
//
//     "...it is not possible to anticipate all SPICE primitives and parameters
//      which could be supported; so different implementations can end up using
//      different names. This level of incompatibility can be overcome by using
//      wrapper modules to map names."
//
// There is no `shall` in it and no mention of a diagnostic; it describes a
// remedy the USER applies. Two further sentences point the other way outright:
// E.2 — "All aspects of SPICE primitives are implementation dependent" — and
// E.4.2 — "Support of SPICE model cards is implementation specific (including
// those using these mechanisms)." Refusing `RSH=50` would make the tool LESS
// able to read the legacy netlists E.1 says the annex exists for, and a fixture
// demanding it would be satisfied by making VerA worse.
//
// The claim is withdrawn outright. It is not moved to another row, because no
// clause in the shipped LRM states it: Annex E leaves card-level parameter
// handling to the implementation, so there is nothing for a conformance fixture
// to pin. What would bring it back: a future LRM edition making the reader's
// behaviour normative, or a VerA policy document declaring a house rule — at
// which point the fixture belongs to whatever row owns that document, not to
// Annex E. Until then the netlist side of this question has no right answer and
// H04 asserts nothing about it.
//
// WHAT THIS FILE CLAIMS INSTEAD, AND WHY IT IS NORMATIVE.
// ---------------------------------------------------------------------------
// Move the same name from the netlist, where Annex E is permissive, into
// Verilog-AMS source, where it is not. Two clauses compose:
//
//   E.3: "Table E.1 shows the required names for primitives, parameters, and
//        ports which are otherwise unnamed in SPICE."
//   Table E.1, `resistor` row: parameter name column reads exactly `r, tc1, tc2`.
//
//   §6.3.3 (Module instance parameter value assignment by name): "Parameter
//        assignment by name explicitly links the parameter name and its value.
//        The name shall be the name specified in the instantiated module."
//
// E.2.2.1 is what makes the second clause bite on a primitive: "The ports and
// parameters of the bjt are determined by the bjt primitive itself and not by
// the model statement for the bjt." The parameters an instance of a Table E.1
// primitive has are the primitive's, and E.3 makes that list required and
// closed. `rsh` is not on it, so `resistor #(.rsh(50))` names a parameter that
// is not "the name specified in the instantiated module" and violates a `shall`.
//
// THIS IS THE GUARD ON THE REST OF THE ROW. Fixtures 01-05 all demand that a
// card's `k=v` values be BOUND to Table E.1 parameters. The cheapest way to
// implement that is to accept any name and create the parameter on demand — at
// which point `#(.rsh(50))` on the primitive itself silently becomes legal and
// Table E.1's required-name list stops meaning anything. This file is what
// stops that: whatever 01-05 make the reader do with unknown card names, the
// Verilog-AMS spelling of an unknown name must still be refused.
//
// WHY THERE IS NO NETLIST IN THIS FILE. `rsh` is written in Verilog-AMS, on a
// primitive the tool always ships, so the fixture does not depend on the
// `//! spice` channel and can be run singly today — which the other ten cannot
// (see tests/fixtures/annex_e_spice/h04_SPEC.md at 8b1514d4). It also keeps the reject attributable: there is exactly one
// thing wrong with this file.
//
// THE SUBSTRING. `E0907` is the code VerA already mints for this, and its text
// names the offending parameter and the module: `override names no parameter of
// the module: `rsh` is not a parameter of `resistor``. Captured, not typed:
//
//     $ ./zig-out/bin/vera --check --contract tools/contract.zig \
//           -I tests/fixtures tests/pending/H04/11_reject_parameter_name_not_in_table_e1.va
//     error[E0907]: override names no parameter of the module: `rsh` is not a
//                   parameter of `resistor`
//        --> tests/pending/H04/11_reject_parameter_name_not_in_table_e1.va:104:14
//         |
//     104 |   resistor #(.rsh(50)) r1(a, b);
//         |              ^
//         |
//         = note: LRM 6.3
//     error: could not compile due to 1 previous error(s)
//     rc=1
//
// SO THIS ONE IS GREEN TODAY, and that is disclosed rather than hidden: the
// refusal already happens and already happens for the right reason. It is a
// regression pin aimed squarely at the change fixtures 01-05 request, which is
// the only reason to keep an already-passing reject. `//! reject E0907` rather
// than a bare `//! reject` or `DiagnosticsReported`, so it cannot be satisfied
// by an unrelated diagnostic (tests/suite.zig:223 accepts any diagnostic for
// a bare `//! reject`).
//
//! lrm E.3
//! lrm E.2.2.1
//! lrm E.1.2
//! lrm 6.3.3
//! lrm 6.3.3:1
//! lrm E.1.2:2
//! bias V(a) = 1.0, V(b) = 0.0
//! reject-only E0907
`include "disciplines.vams"
module h04_reject_unnamed_primitive_param(a, b);
  inout a, b; electrical a, b;
  // Table E.1's resistor row declares exactly r, tc1, tc2. `rsh` is a perfectly
  // ordinary Berkeley resistor-model parameter and is not one of them, so
  // 6.3.3's "the name shall be the name specified in the instantiated module"
  // is violated here and nowhere else in this file.
  resistor #(.rsh(50)) r1(a, b);
  analog begin
    // Unreachable: the instantiation above must not compile. Present so that a
    // tool which accepted `.rsh` would go on to produce a number rather than
    // stopping for some unrelated reason, keeping the reject attributable.
    I(a, b) <+ V(a, b) / 1000.0;
  end
endmodule
