// §9.17.3, on the Table E.2 algorithm E.3.4 spells `fetlim`: "One additional
// argument to the $limit() function is required when the second argument to the
// limit function is the string "fetlim": the third argument to $limit() is
// generally the threshold voltage of the MOS transistor."
//
// "is required" is normative. The call below names "fetlim" and supplies no
// third argument, so it is not a legal $limit() call and must be diagnosed.
//
// WHY THIS IS NOT THE UNKNOWN-STRING CASE. §9.17.3 also says "if the string
// refers to an unknown or unsupported function, the simulator is responsible for
// determining the appropriate limiting algorithm, just as if no string had been
// supplied" — so a tool is free to ignore a string it does not recognise, and no
// fixture may demand a diagnostic for one. "fetlim" is not unknown: it is one of
// the two algorithms §9.17.3 names outright, and naming it is what triggers the
// requirement being violated here. `$limit(V(mid))` with no string at all is
// also legal (syntax 9-12, line 1). The error is naming fetlim and then not
// paying its argument.
//
// WHY THE PROBE IS AN INTERNAL NET. A $limit on a module PORT is one a simulator
// may decline outright (see limit_fet.va), which would mask the arity question
// behind an earlier and unrelated refusal. `mid` is private to the device, so
// the arity is the only thing left to object to.
//
// E0809 ("$limit is missing an argument its algorithm requires") is VerA's code
// for this rule, and it replaces the phase label pinned before the code existed.
//
//! lrm 9.17.3
//! lrm E.3.4
//! reject-only E0809
//! neighbour limit_fet.va
`include "disciplines.vams"
module annex_e_fetlim_missing_vth(p);
  inout p; electrical p; electrical mid; real limited;
  analog begin
    limited = $limit(V(mid), "fetlim");
    I(mid, p) <+ (limited - V(p)) / 1.0;
  end
endmodule
