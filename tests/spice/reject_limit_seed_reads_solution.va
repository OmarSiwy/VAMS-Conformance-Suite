// §9.17.3 `$limit`'s seed argument whose value reads a probe.
//
// A seed is the value a branch starts at BEFORE the first Newton iterate
// (SPICE MODEINITJCT, mos1load.c:397-408). It may read the card and what is
// computed from it (`tVto`), but no solution exists yet: it may never read a
// probe or anything computed from one. E0527 names that.
//! lrm 9.17.3
//! reject-only E0527
`include "disciplines.vams"
module reject_limit_seed_reads_solution(p, n);
  inout p, n; electrical p, n, a;
  parameter real vt = 0.025, vcrit = 0.6;
  real v, vp;
  analog begin
    vp = 0.5 * V(p, n);
    v = $limit(V(a, n), "pnjlim", vt, vcrit, 1.0, vp);
    I(p, a) <+ V(p, a) / 10.0;
    I(a, n) <+ 1e-14 * (limexp(v / vt) - 1.0);
  end
endmodule
