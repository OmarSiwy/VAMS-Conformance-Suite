// §2.9 Syntax 2-4: `attr_spec ::= attr_name [ = constant_expression ]`, for
// every attribute, a vendor's included.
//
// A `$limit` seed computed from the card is `$limit`'s seed argument
// (limit_seed_mos1_initjct.va), where §9.17.3 leaves the algorithm's
// arguments to the implementation. Spelled as an attribute, the same value
// is not a constant_expression: `vtox` is an analog block variable. VerA
// reads no `vera_seed` attribute, so this is the §2.9 rule alone, E0357.
//! lrm 2.9
//! lrm 2.9:2
//! reject-only E0357
//! neighbour limit_seed_mos1_initjct.va
`include "disciplines.vams"
module reject_limit_vera_seed_attr_not_constant(p, n);
  inout p, n; electrical p, n, a;
  parameter real vto = 0.7, vt = 0.025, vcrit = 0.6;
  real vtox, v;
  analog begin
    vtox = vto;
    (* vera_seed = vtox *) v = $limit(V(a, n), "pnjlim", vt, vcrit);
    I(p, a) <+ V(p, a) / 10.0;
    I(a, n) <+ 1e-14 * (limexp(v / vt) - 1.0);
  end
endmodule
