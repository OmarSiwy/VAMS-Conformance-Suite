// Annex B, sentence 2: "An escaped identifier shall not be treated as a
// keyword." That is a `shall not`, and this file tests that half of it —
// escaped_keyword.va tests only the permissive half, that `\if ` may be used
// as a variable.
//
// The clause pinned is §2.8.2: "A Verilog-AMS HDL keyword preceded by an escape
// character is not interpreted as a keyword." §2.8.1 supplies the other half —
// it strips the leading backslash and the terminating white space from the
// identifier — so `\analog ` denotes the ordinary identifier `analog`. It does
// NOT denote the `analog` keyword, so `\analog  begin ... end` is not an
// analog_construct (A.1.4) — an identifier followed by `begin` matches no
// module_item production, and a conforming compiler must reject it.
//
// This is written inside a module so the rule is pinned in a design unit rather
// than at file scope, where a stray identifier would be rejected for boring
// reasons. A compiler that strips the backslash before the keyword lookup — the
// usual way of getting §2.8.1 wrong — accepts this source and fails here.
//
//! lrm B
//! lrm B:1
//! lrm 2.8.1
//! lrm 2.8.2
//! lrm 2.8.2:1000
//! reject-only E0240
//! reject analog
//! neighbour escaped_keyword.va
`include "disciplines.vams"
module annex_b_escaped_keyword_is_not_the_keyword(p, n);
    inout p, n;
    electrical p, n;
    real x;
    \analog  begin x = 1.0; end
endmodule
