// §2.8.2: "All keywords are defined in lowercase only." §2.8 adds "Identifiers
// shall be case sensitive", so the LOWERCASE spellings are the reserved ones and
// nothing else is. That is a two-sided claim, and keyword_case.va tests only
// the permissive side — that `Analog` and `ANALOG` are usable as ordinary
// identifiers, distinct from each other.
//
// This is the other side: `ANALOG` must not be able to ACT as `analog`. A
// compiler that folds keyword case to be forgiving still passes 02 (the names
// are declared, never used as keywords there) and passes every other fixture in
// this chapter, because nothing else asks an upper-case spelling to do a
// keyword's job.
//
// `ANALOG begin ... end` is an identifier followed by `begin`, which matches no
// module_item production in A.1.4; a conforming compiler must reject it.
//! lrm B
//! lrm 2.8
//! lrm 2.8:5
//! lrm 2.8.2
//! lrm 2.8.2:1000
//! reject-only E0240
//! reject ANALOG
//! neighbour keyword_case.va
`include "disciplines.vams"
module annex_b_uppercase_keyword_rejected(p, n);
    inout p, n;
    electrical p, n;
    real x;
    ANALOG begin x = 1.0; end
endmodule
