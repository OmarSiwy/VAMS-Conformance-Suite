// A.9.4 is a closed list, and so is the paragraph it abbreviates:
//
//     white_space ::= space | tab | newline | eof                     // A.9.4
//
//     "White space shall contain the characters for spaces, tabs, newlines, and
//      formfeeds. These characters shall be ignored except when they serve to
//      separate other lexical tokens."                                  §2.3
//
// white_space.va is the positive side: tabs, a formfeed and the `eof`
// alternative, each separating tokens, with a value asserted through them.
// This file is the other side of the same list. The byte between `integer` and
// `x` on line 39 is a VERTICAL TAB (0x0B), written as the raw byte and not as
// an escape. It is in neither list: A.9.4's `tab` and §2.3's "tabs" are the
// horizontal tab, 0x09, and the vertical tab is a separate control character
// that both texts leave out, next to the formfeed that §2.3 takes care to add.
// It is not the start of any other token either (A.9.3 identifiers, A.8.7
// numbers, A.8.6 operators), so the declaration is not derivable: there is no
// separator between the keyword and the name, and no token for the byte.
//
// A lexer that treated every C `isspace` byte as white space would accept this
// file — that is the bug the fixture exists to catch. VerA's lexer produces an
// invalid token for the byte and the declaration parser reports E0208
// "expected an identifier: found invalid token". The code and the phrase
// `invalid token` are pinned; the latter is what says the BYTE was refused,
// rather than some later part of the line.
//
// The `A.9` header is cited with it: A.9 is the parent of A.9.1–A.9.4, and this
// is its reject side alongside reject_A_9_2_nested_block_comment.va and
// reject_A_9_3_identifier_starting_with_digit.va.
//
//! lrm A.9
//! lrm A.9.4
//! lrm 2.3
//! lrm 2.3:1
//! lrm A.9.4:1000
//! reject-only E0208
//! reject invalid token
//! neighbour white_space.va
`include "disciplines.vams"
module annex_a_vertical_tab_is_not_white_space(p, n);
    inout p, n;
    electrical p, n;
    integerx;
    analog I(p, n) <+ V(p, n);
endmodule
