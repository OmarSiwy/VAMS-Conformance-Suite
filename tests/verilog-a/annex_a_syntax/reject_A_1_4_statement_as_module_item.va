// A.1.4, the two productions a module body is made of:
//
//     module_item ::= port_declaration ; | non_port_module_item
//     non_port_module_item ::= module_or_generate_item | generate_region
//             | specify_block | { attribute_instance } parameter_declaration ;
//             | { attribute_instance } specparam_declaration
//             | aliasparam_declaration
//
// and the twelve alternatives of `module_or_generate_item`: declarations,
// `localparam`, `defparam`, `assign`, gate/UDP/module instantiations,
// `initial`, `always`, the two generate constructs and `analog`. Every one of
// them BEGINS with a keyword or an instantiated name; none of them is a bare
// procedural statement. `x = 1;` is a `blocking_assignment` (A.6.2), and the
// only ways A.1.4 reaches one are through the body of `initial`/`always`
// (A.6.2's `statement`) or `analog` (`analog_statement`). At module scope it
// is underivable.
//
// That is also Annex A's opening sentence, which is why `A` and `A.1` are
// cited with it: "The syntax of Verilog-AMS HDL source is derived from the
// starting symbol source_text." A file whose module body holds a statement
// is not derivable from `source_text` by any path, so the whole file is
// refused, not just the line.
//
// The legal forms of the same line are the three the grammar offers: inside
// `analog begin ... end` (A.6.4), inside `initial` (A.6.2), or as a
// declaration initializer where A.2.4 admits one. behavioral_statements.va
// runs the first; analog_initial.va runs an assignment in `analog initial`.
//
// VerA refuses it at the module-item dispatch with E0240 "not a module item",
// naming the identifier that opened the stray statement. The code and that
// phrase are pinned; the parser's recovery after the refusal is not.
//
//! lrm A
//! lrm A.1
//! lrm A.1.4
//! lrm A:1000
//! lrm A.1.4:1000
//! reject-only E0240
//! reject not a module item
//! neighbour behavioral_statements.va
//! neighbour ../../verilog-ams/annex_a_syntax/analog_initial.va
`include "disciplines.vams"
module annex_a_statement_as_module_item(p, n);
    inout p, n;
    electrical p, n;
    integer x;

    x = 1;                    // illegal: a statement is not a module_item

    analog I(p, n) <+ V(p, n);
endmodule
