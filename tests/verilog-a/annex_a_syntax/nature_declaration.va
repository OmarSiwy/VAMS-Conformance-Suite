// A.1.6:
//
//     nature_declaration ::=
//         nature nature_identifier [ : parent_nature ] [ ; ]
//             { nature_item }
//         endnature
//     parent_nature ::= nature_identifier | discipline_identifier . potential_or_flow
//     nature_item ::= nature_attribute
//     nature_attribute ::= nature_attribute_identifier = nature_attribute_expression ;
//
// The `[ : parent_nature ]` bracket is the whole of §3.6.1.1: "A nature can be
// derived from an already declared nature ... the new nature name shall be
// followed by a colon ( : ) and the name of the parent nature". source_text.va
// has the parenthesised attributes of a BASE nature and no derivation at all,
// so this file is where the bracket is reached.
//
// §3.6.1.1's own example is the shape: an alias (`nature ttl_net_curr : ttl_curr;`
// — no items between the header and `endnature`, which is what makes the `{ }`
// repetition legal when empty), and a derived nature that overrides one attribute
// and adds a new one. §3.6.1.2 fixes which attributes those may be: "It is legal
// for a derived nature to change abstol, but if left unspecified it shall inherit
// the abstol from its parent nature", "It is illegal for a derived nature to
// change the access attribute ... the derived nature always inherits the access
// attribute of its parent nature", and (units) "It is illegal for a derived
// nature to define or change the units". So `annex_a_volt_child` moves `abstol`,
// keeps `units` and `access`, and adds the user attribute `maxval`; the two
// attributes it may NOT move are what a compiler that simply copied the base
// nature's item list would get wrong, and they are asserted below.
//
// THE VALUES ARE READ BACK THROUGH A.8.9's nature_attribute_reference,
// `net_identifier . potential_or_flow . nature_attribute_identifier`, which is
// the only expression in the language that names a nature attribute. The child
// is the discipline's POTENTIAL nature and the alias — derived from a second
// base nature, `annex_a_amp` — is its FLOW nature, so one net reaches both:
//
//     p.potential.abstol  is annex_a_volt_child's, because §3.6.2.1 binds
//                         `potential annex_a_volt_child;` as the potential nature
//                         1m =                 and 1m of Table 2-1 is 1e-3
//     p.flow.abstol       is annex_a_amp_alias's, which declares no items at all
//                         and so is its parent's 1p = 1e-12
//
// Both are exact powers of ten: 1e-3 and 1e-12 are not representable in binary,
// but `CHECKX` compares the double the reader got against the double the literal
// `0.001` produces — the same decimal, parsed by the same lexer — so the
// comparison is exact and no tolerance is needed. A compiler that got 1e-6 in
// either place (the parent's value, i.e. no override) reads a different double.
//
// V(p, n) = 0.6 - 0.1 = 0.5 exactly, and `V` is reachable on these nets only
// because the derived nature INHERITED its parent's access attribute: the child
// declares no `access = ...` of its own, and §3.6.1.2 forbids one. §3.12 makes
// the discipline's nature bind the access function, so a compiler that kept the
// child's item list and dropped the parent's would have no `V` here at all.
//
//! lrm A.1.6
//! lrm 3.6.1.1
//! lrm 3.6.1.2
//! lrm 3.6.1.2:1
//! lrm 3.6.1.2:3
//! lrm 3.6.1.2:10
//! lrm 3.6.2.1
//! lrm A.8.9
//! lrm A.1.6:1000
//! lrm A.8.9:1000
//! bias V(p) = 0.6
//! bias V(n) = 0.1
//! print none
//! checks 6
// Own base natures below: D.1's guard keeps annex D's out of check.vh's include.
`define DISCIPLINES_VAMS 1
`include "check.vh"
nature annex_a_volt;
    units = "V";
    access = V;
    abstol = 1u;
endnature

nature annex_a_volt_alias : annex_a_volt;
endnature

nature annex_a_volt_child : annex_a_volt;
    abstol = 1m;
    maxval = 12.3;
endnature

nature annex_a_amp;
    units = "A";
    access = I;
    abstol = 1p;
endnature

nature annex_a_amp_alias : annex_a_amp;
endnature

discipline annex_a_derived;
    domain continuous;
    potential annex_a_volt_child;
    flow annex_a_amp_alias;
enddiscipline

module annex_a_nature(p, n);
    inout p, n;
    annex_a_derived p, n;

    analog begin
        `CHECKX("the derived nature's abstol override is the one in force",
                p.potential.abstol, 0.001);
        `CHECKX("an alias nature that declares no items has its parent's abstol",
                p.flow.abstol, 1e-12);
        `CHECKI("the derived potential nature inherits its parent's units",
                p.potential.units == "V", 1);
        `CHECKI("the empty alias nature inherits its parent's units",
                p.flow.units == "A", 1);
        `CHECKX("a user attribute belongs to the derived nature",
                p.potential.maxval, 12.3);
        `CHECKX("the access function came down from the parent nature", V(p, n), 0.5);
        I(p, n) <+ V(p, n);
    end
endmodule
