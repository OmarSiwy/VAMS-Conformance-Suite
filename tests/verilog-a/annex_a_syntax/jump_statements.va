// A.6.5 `jump_statement ::= return [ expression ] ; | break ; | continue ;`
// is an alternative of A.6.4 `analog_statement`, so all three parse here — but
// §5.11 Jump statements scopes the last one: "The return statement can only be
// used from within an analog user-defined function." The bare `return;` in the
// analog block is the error, and E0403 is the diagnostic for it.
//
// WHY THE `continue` AND `break` ARE NOT A SECOND ERROR. §5.11 also says "The
// continue and break statements cannot be used inside an analog for loop. Refer
// 5.9.3" — and 5.9.3, the clause it refers to, is "Analog for statements", the
// GENVAR loop-generate form (`analog_loop_generate_statement`, A.4.2), which is
// unrolled at elaboration and therefore has no run-time iteration for a jump to
// skip or leave. The loop written below is the ordinary A.6.8
// `analog_loop_statement` over an `integer`, which 5.9.3 does not describe, so
// the restriction does not reach it and the two jumps are legal. They are here
// only to keep the rest of the A.6.5 production covered. Without that reading
// this file would have three errors and E0403 would not be the first one a
// conforming tool reports, so the argument is written down rather than assumed.
//
// The citation used to read "LRM 5.9", which is Looping statements; the
// sentence quoted above is in §5.11. Sibling disable_statement.va already
// documents the same mis-cite.
//
//! lrm A.6.4
//! lrm A.6.5
//! lrm 5.11
//! lrm 5.9.3
//! reject-only E0403
`include "disciplines.vams"
module annex_a_jumps(p); inout p; electrical p; integer i; analog begin for(i=0;i<3;i=i+1) begin if(i==1) continue; if(i==2) break; end return; I(p)<+V(p); end endmodule
