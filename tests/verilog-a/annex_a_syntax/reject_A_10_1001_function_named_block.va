// A.10 detail 1: "Function statements are limited by the rules of 4.7.1."
// One of those rules is 4.7.1's bullet list: an analog function "shall not
// use named blocks". `begin : forbidden` is a named block, so the function
// body is not a legal analog_function_statement.
//
// The reason is 4.7.2.1's return variable: the function's own name denotes
// the value it returns, and a named block (5.3.2) may carry declarations,
// one of which could shadow that variable. The legal form is the unnamed
// `begin ... end` of analog_function.va.
//
// ch04_expressions/function_named_block_ban.va pins the same bullet on
// 4.7.1 itself; this file ties it to Annex A.10's limitation on function
// statements.
//! lrm 4.7.1
//! lrm A.10:1001
//! reject-only E0226
//! reject named block
//! neighbour analog_function.va
`include "disciplines.vams"
module annex_a_fn_named_block(p);
  inout p;
  electrical p;

  analog function real labelled;
    input x;
    real x;
    begin : forbidden         // illegal: an analog function has no named blocks
      labelled = x;
    end
  endfunction

  analog begin
    I(p) <+ labelled(V(p));
  end
endmodule
