// A.6.4 `analog_event_statement` has no `indirect_contribution_statement`
// alternative either — see contribution_in_event_rejected.va for the list.
// §5.10's restriction list is the clause actually violated — it names the
// indirect contribution among the statements an event body may not contain —
// and the reason is in §5.6.7: the indirect form states an equation the solver
// must satisfy across the whole solve, and an event body runs at isolated
// instants. Both are cited; the fixture used to cite 5.6.7 alone, which defines
// the construct and forbids nothing about event control.
//
// It needs its own file because a `//! reject` fixture stops at the first
// diagnostic: with the direct contribution of 26 in the same module, E0406
// fires and E0411 is never reached.
//
//! lrm A.6.4
//! lrm 5.10
//! lrm 5.6.7
//! lrm 5.6.5
//! lrm 5.6.5:2
//! lrm 5.10:2
//! lrm A.6.4:1000
//! reject-only E0411
`include "disciplines.vams"
module annex_a_indirect_in_event(p, c); inout p, c; electrical p, c;
analog begin @(cross(V(p), 1)) V(p) : V(c) == 2.0 * V(p); I(c) <+ 0.0; end
endmodule
