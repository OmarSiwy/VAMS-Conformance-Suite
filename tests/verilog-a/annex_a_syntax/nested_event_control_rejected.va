// A.6.4 `analog_event_control_statement ::= analog_event_control analog_event_statement`,
// and `analog_event_statement` does not list `analog_event_control_statement`
// among its alternatives. So an event control can be the body of nothing: one
// `@(...)` may not be written directly in front of another.
//
// §5.10 makes an event control a single instant at which its body runs. A
// second `@` under the first would have to name an instant inside an instant,
// which the event model has no meaning for.
//
// Both events here are ones a DC operating point can carry (initial_step is
// §5.10.2 global, cross() is §5.10.3.1), so nothing but the nesting is wrong
// with the module.
//
//! lrm A.6.4
//! lrm 5.10
//! lrm 5.10:2
//! lrm A.6.4:1000
//! reject-only E0703
`include "disciplines.vams"
module annex_a_nested_event(p); inout p; electrical p; real x;
analog begin x = 0.0; @(initial_step) @(cross(V(p), 1)) x = 1.0; I(p) <+ x * V(p); end
endmodule
