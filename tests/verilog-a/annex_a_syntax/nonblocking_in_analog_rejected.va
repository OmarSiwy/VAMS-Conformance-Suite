// A.6.2 `analog_procedural_assignment ::= analog_variable_assignment ;` and
// `scalar_analog_variable_assignment ::= scalar_analog_variable_lvalue = analog_expression`
// — the analog form of a variable assignment is the BLOCKING `=` and only
// that. The nonblocking `<=` is A.6.2 `nonblocking_assignment`, reachable only
// from the digital A.6.4 `statement`, because §5.7's analog assignment is
// immediate: there is no event queue inside an analog block to defer to.
//
// The diagnostic reads "expected '<+' or '=': found `;`", which is the useful
// message: in an analog block, `<=` at statement level is almost always a
// mistyped `<+`.
//
// The suite's other nonblocking fixture (ch07_mixed_signal/m02_10_macro_process_-
// runs_after_nba.va) writes `always @(posedge clk) q <= d;`, where `<=` is legal
// and runs; no fixture put `<=` at analog statement level before this one.
//
//! lrm A.6.4
//! lrm A.6.2
//! lrm 5.7
//! lrm A.6.2:1000
//! lrm A.6.4:1000
//! reject-only E0214
`include "disciplines.vams"
module annex_a_nonblocking_in_analog(p); inout p; electrical p; real x;
analog begin x <= 1.0; I(p) <+ x * V(p); end
endmodule
