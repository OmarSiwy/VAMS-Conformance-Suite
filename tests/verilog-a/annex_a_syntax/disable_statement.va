// A.6.5 `disable_statement ::= disable hierarchical_block_identifier ;`
//
// It is an alternative of A.6.4 `analog_event_statement` and of the digital
// A.6.4 `statement`. It is ABSENT from A.6.4 `analog_statement`, so the only
// form an analog block can legally contain is
//
// @(<event>) disable <named_block>;
//
// This fixture writes `analog begin : work ... disable work; ... end`, i.e.
// `disable` in analog_statement position, which no production derives. The
// rejection is therefore CORRECT behaviour, not a missing feature.
//
// Citation note: there is no clause-5 section for `disable` — 5.11 is
// `jump_statement` (return/break/continue) — so annex A is the citation. The
// engine used to cite "LRM 5.11"; that was wrong and is fixed.
//
//! lrm A.6.4
//! lrm A.6.5
//! lrm A.6.4:1000
//! reject-only E0401
`include "disciplines.vams"
module annex_a_disable(p); inout p; electrical p; analog begin : work if(V(p)>1.0) disable work; I(p)<+V(p); end endmodule
