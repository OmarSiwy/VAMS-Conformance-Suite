// A.1.2 `description ::= module_declaration | udp_declaration | config_declaration
//                      | paramset_declaration | nature_declaration
//                      | discipline_declaration | connectrules_declaration`
//
// Three of those alternatives appear here, and the natures and the discipline
// are not decoration: the nets of the module below are bound to the DECLARED
// `annex_a_electrical`, not to the built-in `electrical`, so a compiler that
// parsed the declarations and discarded them cannot resolve `V(p, n)` at
// all. §3.6.2.1 binds `annex_a_voltage` as the discipline's potential nature and
// §3.13.2 makes that nature's `access = V` the function that reads it, so the
// probe below runs through the user's own declarations end to end. Before this
// the module bound its nets with the BUILT-IN `electrical` and asserted nothing,
// so all of the declarations were dead text.
//
// THE FLOW NATURE IS LOAD-BEARING TOO. With only `potential annex_a_voltage;`
// the discipline has a single nature, which §3.6.2.1 calls a signal-flow
// discipline, and §3.12 says such a branch "defines either a branch potential
// or a branch flow, but not both". §5.4.1: "The name of the access function is
// taken from the discipline of the net." So `I(p, n)` named an access function
// the declared discipline did not define — source a conforming compiler must
// diagnose, green here only because VerA resolves the built-in `I` globally,
// which also refuted this header's own claim that the probe runs through the
// user's declarations end to end. `annex_a_current` and the `flow` binding fix
// that and cover the second half of §3.6.2.1 the header claims.
//
// V(p) - V(n) = 0.6 - 0.1. Neither operand is representable in binary, but
// their difference is: the nearest doubles to 0.6 and 0.1 subtract to exactly
// 0.5 (verified, not assumed), so this is `CHECKX` and not a tolerance.
//
// `module annex_a_first();` uses A.1.3's non-ANSI `list_of_ports`, whose
// single `port` can be empty through `[ port_expression ]`. Unlike IEEE2005,
// AMS2023 has no empty ANSI list_of_port_declarations alternative.
// This is a module with no ports at all. It is legal, it is here for that
// production alone, and it contributes no assertion; it must PARSE, nothing
// more. It is written second on purpose: a device is elaborated from the FIRST
// module in the file, and a portless one has no port to bias or probe, so this
// fixture's own assertions would have nothing to stand on. (It used to be the
// README's CANNOT RUN case as well, which would have swallowed the whole file;
// that verdict is retired — ch06_hierarchy/module_definition.va now runs.)
//
// `A` (the annex, whose first sentence is that source "is derived from the
// starting symbol source_text") and `A.1` (Source text, the heading over
// A.1.1–A.1.9) are cited as well: this file derives from `source_text`
// through A.1.2 and states nothing either heading does not.
//
//! lrm A
//! lrm A.1
//! lrm A.1.2
//! lrm A.1.3
//! lrm 3.6.2.1
//! lrm 3.13.2
//! lrm A:1000
//! lrm A.1.2:1000
//! lrm A.1.6
//! lrm A.1.6:1000
//! lrm A.1.7
//! lrm A.1.7:1000
//! bias V(p) = 0.6
//! bias V(n) = 0.1
//! print none
// Own base natures below: D.1's guard keeps annex D's out of check.vh's include.
`define DISCIPLINES_VAMS 1
`include "check.vh"
nature annex_a_voltage;
    units = "V";
    access = V;
    abstol = 1u;
endnature

nature annex_a_current;
    units = "A";
    access = I;
    abstol = 1p;
endnature

discipline annex_a_electrical;
    domain continuous;
    potential annex_a_voltage;
    flow annex_a_current;
enddiscipline

module annex_a_source_text(p, n);
    inout p, n;
    annex_a_electrical p, n;
    analog begin
        `CHECKX("the user-declared nature's access function reaches the node pair",
                V(p, n), 0.5);
        I(p, n) <+ V(p, n);
    end
endmodule

module annex_a_first();
endmodule
