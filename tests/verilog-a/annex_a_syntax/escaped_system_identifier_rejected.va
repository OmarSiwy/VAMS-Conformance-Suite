// A.10 detail 4, second sentence: "A system_function_identifier or
// system_task_identifier shall not be escaped."
//
// §2.8.1 says an escaped identifier "starts with the backslash character (\)
// and ends with white space" and that the backslash and the terminating white
// space are not part of the name. So `\$vt ` is not the system parameter $vt at
// all: it is an ORDINARY identifier whose name happens to be the three
// characters `$vt`, and it has not been declared. The diagnostic is therefore
// an unknown identifier, not a syntax error — which is exactly the point of the
// rule, because the escape silently changes what the token means instead of
// being rejected as a spelling of $vt.
//
// The first sentence of the same detail ("The $ character ... shall not be
// followed by white_space") is pinned by ch02_lexical/system_whitespace_rejected.va.
// This second sentence had no fixture anywhere in the suite.
//
//! lrm A.10
//! lrm A.10:4
//! lrm 2.8.1
//! lrm 2.8.3
//! lrm 2.8.3:2
//! reject-only E0314
`include "disciplines.vams"
module annex_a_escaped_system(p); inout p; electrical p; real x;
analog begin x = \$vt ; I(p) <+ x * V(p); end
endmodule
