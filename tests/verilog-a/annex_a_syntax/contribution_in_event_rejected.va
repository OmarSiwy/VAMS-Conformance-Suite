// A.6.4 `analog_event_control_statement ::= analog_event_control analog_event_statement`
// and the `analog_event_statement` list, in full:
//
//   analog_loop_statement | analog_case_statement | analog_conditional_statement
//   | analog_procedural_assignment | analog_event_seq_block
//   | analog_system_task_enable | disable_statement | event_trigger | ;
//
// `contribution_statement` is NOT on it — it is an alternative of
// `analog_statement` only. §5.10 gives the reason: "Contribution statements
// cannot be used inside an event control block because it can generate
// discontinuity in analog signals." A branch value has to hold over the whole
// solve; an event body runs at isolated instants.
//
// The event is `cross()`, not a named event, on purpose: the two files that
// contained this construct before both declared an `event` first and died on
// E0203 "named event declaration is not implemented" without ever reaching the
// contribution, so the rule had zero fixtures pinning it. The second,
// unconditional contribution keeps the module a well-formed device otherwise,
// so E0406 is the only thing wrong with it.
//
//! lrm A.6.4
//! lrm 5.10
//! lrm 5.6.5
//! lrm 5.6.5:2
//! lrm 5.10:2
//! lrm A.6.4:1000
//! reject-only E0406
`include "disciplines.vams"
module annex_a_contribution_in_event(p, n); inout p, n; electrical p, n;
analog begin @(cross(V(p, n), 1)) I(p, n) <+ V(p, n); I(p, n) <+ 0.0; end
endmodule
