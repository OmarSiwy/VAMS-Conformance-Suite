// A.6.10 `contribution_statement ::= branch_lvalue <+ analog_expression ;`
// and A.8.5 `branch_lvalue ::= branch_probe_function_call` — the left side of
// `<+` is an access function applied to a branch, never a variable. A variable
// takes `=` (A.6.2 `analog_procedural_assignment`); the two are different
// statements with different semantics, §5.6.1 vs §5.7.
//
// `x <+ 1.0` therefore derives from no production. It is worth its own fixture
// because it is the shape a `<+`/`=` slip produces, and until now no fixture in
// the suite wrote a contribution whose lvalue was not V(...) or I(...), so a
// compiler that accepted this passed everything.
//
//! lrm A.6.10
//! lrm A.8.5
//! lrm 5.6.1
//! lrm 5.6.1:2
//! lrm A.6.10:1000
//! lrm A.8.5:1000
//! reject-only E0408
//! neighbour indirect_contribution.va
`include "disciplines.vams"
module annex_a_contribution_to_variable(p); inout p; electrical p; real x;
analog begin x <+ 1.0; I(p) <+ V(p); end
endmodule
