// A.1.3's named port keeps its parentheses when it has no expression:
//
//     port ::= [ port_expression ] | . port_identifier ( [ port_expression ] )
//
// `.x()` is a port named x that connects to nothing inside (§6.5.1: "The port
// expression is optional because ports can be defined which do not connect to
// anything internal to the module"); `.x` alone is neither alternative, as
// §6.5.5 says of the instance-side form: "The parentheses are required."
// VerA refuses it with E0207 at the comma where the `(` must be. The
// neighbour writes `.x()`.
//
//! lrm A.1.3
//! lrm 6.5.1
//! reject-only E0207
//! reject found `,`
//! neighbour null_port_connects_nothing.va
`include "disciplines.vams"
module null_port_named_without_parentheses(.x, a, b);
    inout a, b;
    electrical a, b;

    analog I(a, b) <+ V(a, b);
endmodule
