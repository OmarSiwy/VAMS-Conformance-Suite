// A.2.5:
//
//     value_range ::=
//             value_range_type ( value_range_expression : value_range_expression )
//             | ... (the other three interval forms)
//             | value_range_type '{ string { , string } }
//             | exclude constant_expression
//
// The brace-list form is a list of STRINGS only (it restricts a string
// parameter to an enumerated set). `from '{1.0, 2.0}` puts reals in it, which
// no alternative derives; a real parameter is ranged with an interval such as
// `from [1.0:2.0]`. The string form, `parameter string s = "a" from '{"a", "b"};`,
// compiles (probed).
//
// VerA reports E0207 "unexpected token: found 1.0".
//
//! lrm A.2.5
//! lrm A.2.5:1000
//! reject-only E0207
//! neighbour ../../verilog-ams/annex_a_syntax/specparam_range_and_select.va
`include "disciplines.vams"
module annex_a_numeric_value_list(p, n);
  inout p, n;
  electrical p, n;
  parameter real k = 1.0 from '{1.0, 2.0};   // illegal: '{...} holds strings only
  analog I(p, n) <+ k * V(p, n);
endmodule
