// A.8.1:
//
//   assignment_pattern ::= '{ expression { , expression } }
//                        | '{ constant_expression { expression { , expression } } }
//
// derives no empty element. Only §3.6.3.2's bus nodeset gives a hole a meaning
// ("a null value in the constant array indicates that no nodeset value is
// being specified for this element"); a parameter default is not a nodeset, so
// `'{1.0, , 3.0}` here has no second value: E0894. Before 2026-10-08 VerA read
// the hole as 0.0 with no diagnostic (found by the Annex A grammar oracle,
// `tools/conformance.py grammar`).
//
// The neighbour writes the element.
//
//! lrm A.8.1
//! lrm 3.4.4
//! reject-only E0894
//! neighbour pattern_every_element_written.va
`include "disciplines.vams"
module pattern_empty_element_rejected(p, n);
  inout p, n; electrical p, n;
  parameter real a[0:2] = '{1.0, , 3.0};
  analog I(p, n) <+ a[1] * V(p, n);
endmodule
