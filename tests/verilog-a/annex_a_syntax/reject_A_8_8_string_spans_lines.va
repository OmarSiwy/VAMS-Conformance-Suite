// A.8.8 and the sentence of §2.7 that bounds it:
//
//     string_literal ::= " { Any_ASCII_Characters } "                 // A.8.8
//
//     "A string literal is a sequence of characters enclosed by double quotes
//      (") and contained on a single line."                             §2.7
//
// The production closes on a `"`. Here the opening quote on line 35 is followed
// by a newline before any closing quote: the characters between the quotes
// would include the line break, which §2.7 excludes, and the `"` that
// eventually appears on the next line opens a second, equally unterminated
// literal rather than closing the first. Table 2-2's `\n` is how a string
// SPELLS a newline; string_literal.va runs that and asserts its value, 10.
//
// VerA's lexer stops the literal at the end of the line and reports E0138 "a
// string literal may not span lines" there. Anything the parser reports while
// recovering from the broken statement is not the rule and is not pinned.
//
// The `A.8` header is cited with it: A.8 is the parent of A.8.1–A.8.9, and
// this file is where its reject side is measured (expressions.va is the
// positive side).
//
//! lrm A.8
//! lrm A.8.8
//! lrm 2.7
//! lrm A.8.8:1000
//! reject-only E0138
//! reject may not span lines
//! neighbour expressions.va
//! neighbour string_literal.va
`include "disciplines.vams"
module annex_a_string_spans_lines(p, n);
    inout p, n;
    electrical p, n;
    integer code;

    analog begin
        code = "A
B";
        I(p, n) <+ V(p, n);
    end
endmodule
