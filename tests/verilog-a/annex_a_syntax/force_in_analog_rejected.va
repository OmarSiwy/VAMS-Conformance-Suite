// A.6.2 `procedural_continuous_assignments ::= assign ... | deassign ... |
// force ... | release ...` is an alternative of the DIGITAL A.6.4 `statement`
// only. The A.6.4 `analog_statement` list has eleven alternatives and none of
// them is a procedural continuous assignment, so `force x = 1.0;` inside an
// `analog` block derives from nothing.
//
// In a digital `initial` block the same statements are legal and run
// (ch08_scheduling/procedural_continuous_semantics.va and
// procedural_assign_deassign_semantics.va). This one puts the construct where
// the grammar is the only thing that can refuse it.
//
// One file, not four: release/assign/deassign take the same parser path and the
// same code. Split them the day that path diverges.
//
// E0258 names A.6.2; until 2026-10 this was the parser's generic E0209
// "expected an expression".
//
//! lrm A.6.4
//! lrm A.6.2
//! lrm A.6.4:1000
//! reject-only E0258
//! neighbour ../../verilog-ams/ch08_scheduling/procedural_continuous_semantics.va
`include "disciplines.vams"
module annex_a_force_in_analog(p); inout p; electrical p; real x;
analog begin force x = 1.0; I(p) <+ V(p); end
endmodule
