// §3.6.3/§3.6.1.2 again, one step further than domainless_discipline.va: a
// DOMAINLESS discipline binds neither a domain nor a nature (§3.6.2.3), so a net
// of it has no potential access function and cannot be contributed to. §3.6.2.4
// adds the second reason for this file: a net with no discipline that IS
// referenced in behavioral code "shall be treated as having no discipline with a
// domain binding of discrete", and a discrete net is not something an analog
// contribution can drive.
//
// As in 79, VerA refuses it with E0501: `V` is not an access function of `link`.
//
//! lrm 3.6.3
//! lrm 3.6.3:1001
//! lrm 3.6.2.3
//! reject-only E0501
//! neighbour domainless_discipline.va
`include "disciplines.vams"
discipline ch3_domainless_beh;
enddiscipline

module ch3_domainless_behavioral(p);
    inout p;
    electrical p;
    ch3_domainless_beh link;

    analog begin
        V(link) <+ 1.0;
        I(p) <+ 0.0 * V(p);
    end
endmodule
