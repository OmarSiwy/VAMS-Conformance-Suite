// §3.3 Table 3-3, the Replication row: "multiplier must be of integral type and
// can be nonconstant." The permission to be nonconstant comes with the type
// requirement in the same sentence. Here the multiplier is `x`, a `real`
// variable set from a probe: nonconstant, and not of integral type.
//
// The CONSTANT real multiplier is a different rule and legal: §4.2.1 converts
// a real replication constant to an integer first (replication_real_count.va
// in ch04_expressions). That conversion is a compile-time one; a real known
// only at run time falls under the row's "must be of integral type", which
// VerA reports with E0327's "shall be of integral type" message.
//
// string_replication_runtime_multiplier.va is the legal neighbour: the same
// replication with an `integer` multiplier.
//
//! lrm 3.3
//! lrm 3.3:4
//! reject-only nonconstant replication multiplier shall be of integral type
//! neighbour string_replication_runtime_multiplier.va
`include "disciplines.vams"
module ch3_replication_nonconstant_real_multiplier_rejected(p);
    inout p;
    electrical p;
    real x;
    string a;

    analog begin
        x = V(p) > 0.5 ? 2.0 : 3.0;
        a = {x{"Hi"}};
        I(p) <+ 0.0 * V(p);
    end
endmodule
