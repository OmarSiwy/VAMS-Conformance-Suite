// §3.4.7 requires the original name even inside an instantiated child.
// Elaboration must diagnose this source before renaming its declarations.
// aliasparam_source_bindings.va legally overrides an alias on the child and
// reads only its original parameter in that child's equations.
//! lrm 3.4.7
//! reject-only E0373
//! neighbour aliasparam_source_bindings.va
`include "disciplines.vams"
module aliasparam_child_top(p);
  inout p; electrical p;
  aliasparam_child_bad #(.alternate(3)) child(p);
endmodule
module aliasparam_child_bad(p);
  inout p; electrical p;
  parameter real gain=1;
  aliasparam alternate=gain;
  analog I(p) <+ alternate*V(p);
endmodule
