// §3.13.3: "Access functions are uniquely defined for each net based on the
// discipline of the net. Each access function is used with the name of the net
// as its argument and a net can only be accessed THROUGH ITS ACCESS FUNCTIONS."
//
// `level = p;` reads the net `p` with no access function at all. A net is not a
// value: `p` names a node of the circuit, and until an access function is
// applied there is no way to say whether the number wanted is its potential or
// its flow. `level = V(p);` is the legal spelling and is one character longer.
//
// wrong_access_function.va is the neighbouring case — an access function that
// exists but belongs to another nature — and it is a different code path: there
// the name resolves as a function and fails on which net it may take, here
// there is no function at all.
//
//! lrm 3.13.3
//! lrm 3.13.3:1000
//! reject-only E0315
//! neighbour net_and_branch_hierarchical_reference.va
`include "disciplines.vams"
module ch3_bare_net_name_not_a_value(p, n);
    inout p, n;
    electrical p, n;
    real level;

    analog begin
        level = p;
        I(p, n) <+ level * V(p, n);
    end
endmodule
