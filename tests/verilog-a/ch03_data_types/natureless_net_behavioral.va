// §3.6.3/§3.6.1.2: a net's access function comes from the `access` attribute of
// the nature bound to its discipline. A NATURELESS discipline binds no nature
// (§3.6.2.3), so a net of it has no potential access function at all and `V` —
// which is `electrical`'s spelling, from `Voltage` in annex D — names nothing
// for it. Contributing to `V(link)` is therefore an error, and it is the one
// error natureless_discipline.va deliberately stops short of: everything in
// that file is legal, and this is the first line that is not.
//
// VerA refuses it with E0501, "`V` is not an access function of `link`" —
// the rule itself.
//
//! lrm 3.6.3
//! lrm 3.6.3:1001
//! lrm 3.6.2.3
//! reject-only E0501
//! neighbour natureless_discipline.va
`include "disciplines.vams"
discipline ch3_natureless_beh;
    domain continuous;
enddiscipline

module ch3_natureless_behavioral(p);
    inout p;
    electrical p;
    ch3_natureless_beh link;

    analog begin
        V(link) <+ 1.0;
        I(p) <+ 0.0 * V(p);
    end
endmodule
