// §3.4.3: "The standard attributes for descriptions and units, described in
// 2.9.2, can be used for parameters." The form those attributes take is the
// one §2.9.2 fixes, and §2.9.2 points straight back here: "The desc attribute
// is used to generate help messages when attached to parameter, variable and
// net declarations within a module. The attribute must be assigned a string.
// See 3.4.3."
//
// So the parameter description §3.4.3 permits is a STRING. `desc = 42` is an
// integer constant on a parameter declaration and nothing else is wrong: with
// `desc = "gain"` the same file is ch02_lexical/attributes.va's legal form
// (checked by hand when this fixture was written). ch02_lexical/69 and 70 pin
// the same §2.9.2 rule without the §3.4.3 citation; this row is the parameter
// half of §3.4.3 specifically.
//
//! lrm 3.4.3
//! lrm 2.9.2
//! lrm 2.9.2:1
//! lrm 2.9.2:2
//! reject-only E0358
//! neighbour ../ch02_lexical/attributes.va
`include "disciplines.vams"
module ch3_parameter_desc_attribute_numeric(p, n);
    inout p, n;
    electrical p, n;
    (* desc = 42, units = "S" *) parameter real gain = 1.0;
    analog I(p, n) <+ gain * V(p, n);
endmodule
