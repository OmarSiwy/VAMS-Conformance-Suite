// §3.6.3.2: "The initializer shall be a constant_expression and will be used as
// a nodeset value for the potential of the net by the analog solver."
//
// A nodeset is the solver's STARTING POINT — it is chosen once, before the
// first iteration exists. `V(p)` is the opposite of that: it is the potential
// the solve is looking for, so at the moment the initializer is needed it has
// no value, and at the moment it has one the initializer is no longer wanted.
//
// net_nodeset.va is the legal half of the same production, and the sibling
// rule one clause up is parameter_default_not_constant_rejected.va (E0363):
// a parameter default reading `$abstime`. Both are the same sentence in the
// grammar — the position says constant_expression and the source wrote a read
// of the operating point — which is why the two diagnostics are neighbours.
//
// A PARAMETER reference is not this error: §3.4 makes one a constant
// expression, and `electrical n = vstart;` is the form a model card tunes.
// nodeset_over_parameter.va pins that it compiles.
//
// This file exists because the initializer used to be parsed and thrown away,
// which made every expression in that position equally legal.
//
//! lrm 3.6.3.2
//! lrm 3.6.3.2:1
//! reject-only E0365
//! neighbour net_nodeset.va
//! neighbour nodeset_over_parameter.va
`include "disciplines.vams"
module ch03_nodeset_not_constant(p, n);
    inout p, n;
    electrical p, n;
    electrical mid = V(p);

    analog begin
        I(p, mid) <+ V(p, mid);
        I(mid, n) <+ V(mid, n);
    end
endmodule
