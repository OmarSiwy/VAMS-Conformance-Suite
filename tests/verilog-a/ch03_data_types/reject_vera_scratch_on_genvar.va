// VerA's `vera_scratch` attribute (§2.9) on a genvar declaration.
//
// The attribute says a variable (§3.2) starts every evaluation afresh. A
// genvar (§3.5) exists only while loops are unrolled and has no storage in
// the device at all. E0535 names that. The legal neighbour, the same attribute
// on a variable declaration, is in vera_scratch_starts_each_evaluation.va.
//! lrm 2.9
//! reject-only E0535
//! neighbour vera_scratch_starts_each_evaluation.va
`include "disciplines.vams"
module reject_vera_scratch_on_genvar(p, n);
  inout p, n; electrical p, n;
  (* vera_scratch *) genvar i;
  analog begin
    for (i = 0; i < 2; i = i + 1)
      I(p, n) <+ V(p, n) / 1k;
  end
endmodule
