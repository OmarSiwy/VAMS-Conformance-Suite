// §3.4.7's rule applies to a hierarchical geometry alias too. Flattening
// currently represents the alias's resolved value as a local parameter;
// that implementation detail must not make a forbidden source read legal.
// ch09_system_tasks/geometry_defparam_alias.va is the legal binding neighbour.
//! lrm 3.4.7
//! reject-only E0373
//! neighbour ../ch09_system_tasks/geometry_defparam_alias.va
`include "disciplines.vams"
module aliasparam_geometry_top(p);
  inout p; electrical p;
  aliasparam_geometry_child #(.placement(2)) child();
  analog I(p) <+ child.placement*V(p);
endmodule
module aliasparam_geometry_child;
  aliasparam placement=$xposition;
endmodule
