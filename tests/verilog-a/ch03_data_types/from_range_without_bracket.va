// §3.4.2 / A.2.5: the bare-expression form of a value range belongs to
// `exclude` alone —
//
//     range ::= from value_range | exclude value_range | exclude constant_expression
//
// so `from 5` has no production. Its sibling `exclude 5` is legal and
// parameter_ranges.va exercises it; the two forms differ by one keyword,
// which is exactly why the illegal one is easy to write by hand.
//
// This file exists because the parser used to answer it with
// `std.debug.assert(kind == .exclude)`: a crash in a checked build and, in
// ReleaseFast, `unreachable` — undefined behaviour selected by a source file,
// i.e. at the trust boundary. A grammar rule about user input is a diagnostic,
// never an assert, so the pinned substring is the code and not just the phase.
//
//! lrm 3.4.2
//! reject-only E0207
//! neighbour parameter_ranges.va
`include "disciplines.vams"
module ch3_from_range_without_bracket(p, n);
    inout p, n;
    electrical p, n;
    parameter real gain = 1 from 5;

    analog begin
        I(p, n) <+ gain * V(p, n);
    end
endmodule
