// §3.4: "the initializer ... shall be a constant expression, that is, an
// expression containing only constant numbers and previously defined
// parameters."
//
// `scratch` is a real VARIABLE. It is declared before the parameter, so it
// satisfies the ordering half that forward_parameter_reference.va tests, and
// it is still not admissible: the permitted set is constant numbers and
// parameters, and a variable is neither. Its value does not even exist until
// the analog block runs, which is after every parameter has had to be resolved.
//
// Replacing `scratch` with a literal, or with a parameter declared above, makes
// the file legal.
//
// VerA refuses it with E0363, "parameter default is not a constant expression:
// `slope` reads `scratch`" — the §3.4 rule. forward_parameter_reference.va
// pins E0314 for the other half: a name not yet defined at the point of use.
//
//! lrm 3.4
//! lrm 3.4:1
//! reject E0363
`include "disciplines.vams"
module ch3_variable_in_parameter_initializer(p, n);
    inout p, n;
    electrical p, n;
    real scratch;
    parameter real slope = scratch;

    analog begin
        scratch = 1.0;
        I(p, n) <+ slope * V(p, n);
    end
endmodule
