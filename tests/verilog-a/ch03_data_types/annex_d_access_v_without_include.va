// §3.13.2: "Each access function name, defined before a module is parsed, is
// automatically added to that module's namespace ... Furthermore, the access
// function of each base nature shall be unique."
//
// VerA preloads annex D (D.1 `disciplines.vams`) into every compilation, so
// Voltage (access V) and Current (access I) are declared whether or not the
// source asks for them. specification/Vague_Decisions.md VD-096 decides that those
// preloaded natures take part in §3.13.2's rule only when the source includes
// D.1 itself. This source does not, so its own base natures ch3_vd096_volt
// (access V) and ch3_vd096_amp (access I) are the only base natures it
// declares with those access functions, and it is legal.
// `annex_d_access_v_included_rejected.va` is the same text plus the include,
// and is refused (E0335).
//
// BY HAND. `p` is of discipline ch3_vd096_elec, so `V(p)` is the potential of
// its potential nature, ch3_vd096_volt (§4.4: the access function is the
// discipline's). Biased at 0.5, `V(p)` reads 0.5. The nature's abstol is 1m,
// where annex D's Voltage has 1e-6 (D.1), so both the §5.5.3 attribute read
// `p.potential.abstol` and the published §3.6.1.2 node tolerance (`//! abstol`)
// say which nature `p` got: 1e-3, not 1e-6. Three checks: two CHECKs and the
// abstol line.
//
//! lrm 3.13.2
//! lrm 3.6.1.2
//! bias V(p) = 0.5
//! abstol p = 1e-3
//! checks 3
// Own base natures below: D.1's guard keeps annex D's out of check.vh's include.
`define DISCIPLINES_VAMS 1
`include "check.vh"
nature ch3_vd096_volt; units = "V"; access = V; abstol = 1m; endnature
nature ch3_vd096_amp; units = "A"; access = I; abstol = 1n; endnature
discipline ch3_vd096_elec; potential ch3_vd096_volt; flow ch3_vd096_amp; enddiscipline
module ch3_vd096(p);
  inout p; ch3_vd096_elec p;
  analog begin
    I(p) <+ V(p) / 2k;
    `CHECKX("V reads the user nature's potential", V(p), 0.5);
    `CHECKR("p's potential nature is the user's, abstol 1m", p.potential.abstol, 1e-3, 1e-12);
  end
endmodule
