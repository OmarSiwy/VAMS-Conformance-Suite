// §3.4.7 requires the original name in equations, including a condition
// whose value can be folded before its body is lowered. The condition must
// read gain. parameter_alias.va is the legal override/read neighbour.
//! lrm 3.4.7
//! lrm 3.4.7:3
//! reject-only E0373
//! neighbour parameter_alias.va
`include "disciplines.vams"
module aliasparam_condition(p);
  inout p; electrical p;
  parameter integer gain=1;
  aliasparam alternate=gain;
  analog if (alternate == 1) I(p) <+ V(p);
endmodule
