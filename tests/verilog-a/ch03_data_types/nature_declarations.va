// §3.6.1 nature declarations, and §3.6.1.1 derived natures. Per §3.6.1.2 a derived nature
// may change `abstol` and add attributes of its own, but "it is illegal for a
// derived nature to change the access attribute; the derived nature always
// inherits the access attribute of its parent nature".
//
// That inheritance is only observable through a net, so `ch03_hv_disc` binds
// the DERIVED nature as its potential and `hv_p`/`hv_n` are nets of it. Nothing
// in `ch03_high_voltage` says `access = V` — that name comes from the parent —
// and the bias makes the value it returns a number rather than a compile check.
//
//! lrm 3.6.1
//! lrm 3.6.1.1
//! lrm 3.6.1.2
//! lrm 3.6.1.2:3
//! lrm 3.6.1:1
//! lrm 3.6.1.1:1
//! lrm 3.13.1:1000
//! bias V(hv_p) = 4, V(hv_n) = 1
// Own base natures below: D.1's guard keeps annex D's out of check.vh's include.
`define DISCIPLINES_VAMS 1
`include "check.vh"
nature ch03_voltage;
    units = "V";
    access = V;
    abstol = 1u;
endnature

nature ch03_high_voltage : ch03_voltage;
    abstol = 1m;
    maxval = 12.3;
endnature

nature ch03_hv_current;
    units = "A";
    access = I;
    abstol = 1p;
endnature

discipline ch03_hv_disc;
    domain continuous;
    potential ch03_high_voltage;
    flow ch03_hv_current;
enddiscipline

module ch03_nature_declarations(p, n);
    inout p, n;
    ch03_hv_disc p, n;
    ch03_hv_disc hv_p, hv_n;

    analog begin
        `CHECKX("the derived nature inherits access V from its parent", V(hv_p, hv_n), 3.0);
        I(p, n) <+ V(p, n);
        I(hv_p, hv_n) <+ 0.01 * V(hv_p, hv_n);
    end
endmodule
