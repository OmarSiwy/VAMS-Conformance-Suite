// VerA's `(* vera_scratch = "uninit" *)` (§2.9) on a declaration with an
// initializer.
//
// "uninit" says the variable starts every evaluation with no value; the §3.2
// declaration initializer says it starts at one. The two contradict, so
// E0539 refuses the pair rather than pick one. The legal neighbour, plain
// `(* vera_scratch *)` with an initializer (restarted at it every
// evaluation), is `zr` in vera_scratch_uninit_tape.va.
//! lrm 2.9
//! reject-only E0539
//! neighbour vera_scratch_uninit_tape.va
`include "disciplines.vams"
module reject_vera_scratch_uninit_initializer(p, n);
  inout p, n; electrical p, n;
  integer k;
  (* vera_scratch = "uninit" *) real st[0:3] = '{1, 2, 3, 4};
  analog begin
    k = ($abstime < 0.5) ? 1 : 2;
    st[k] = V(p, n);
    I(p, n) <+ st[k];
  end
endmodule
