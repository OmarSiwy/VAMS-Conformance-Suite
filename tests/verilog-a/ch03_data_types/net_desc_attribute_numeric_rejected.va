// §3.6.3.1: "Nets can be declared with a description attribute. This
// information can be used by the simulator to generate help messages for a
// module. Example: (* desc="drain terminal" *) electrical d;"
//
// The description attribute is §2.9.2's `desc`, whose row names nets among
// its subjects and fixes its form: "The desc attribute is used to generate
// help messages when attached to parameter, variable and net declarations
// within a module. The attribute must be assigned a string."
//
// `(* desc = 7 *) electrical d;` is §3.6.3.1's own example with the string
// replaced by an integer constant, and nothing else in the file is wrong: with
// `desc = "drain terminal"` it is net_and_port_description_attributes.va's legal form (checked by hand
// when this fixture was written).
//
//! lrm 3.6.3.1
//! lrm 2.9.2
//! lrm 2.9.2:1
//! lrm 2.9.2:2
//! reject-only E0358
//! neighbour net_and_port_description_attributes.va
`include "disciplines.vams"
module ch3_net_desc_attribute_numeric(p, n);
    inout p, n;
    electrical p, n;
    (* desc = 7 *) electrical d;

    analog begin
        I(p, d) <+ V(p, d) / 1000.0;
        I(d, n) <+ V(d, n) / 1000.0;
    end
endmodule
