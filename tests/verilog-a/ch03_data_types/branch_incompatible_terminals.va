// §3.12: "Each branch declaration is associated with two nets from which it
// derives a discipline. These nets are referred to as the branch terminals. ...
// The disciplines for the specified nets shall be compatible (see 3.11)."
//
// `elec` is electrical and `shaft` is rotational, which §3.11.1 names as its
// worked incompatible pair: "electrical and rotational are incompatible
// disciplines because the natures for both potential and flow are not derived
// from the same base natures". A branch over them has no discipline to derive,
// so it has no access functions either.
//
// Distinct from incompatible_nets_access.va: that one is the access function
// applied to two nets, this one is the branch DECLARATION, and §3.12 states the
// requirement separately because a compiler can check one and not the other.
//
// VerA refuses it with E0355, "incompatible disciplines" — the §3.11 rule.
//
//! lrm 3.12
//! lrm 3.12:1
//! lrm 3.11
//! reject-only E0355
//! neighbour named_branches.va
`include "disciplines.vams"
module ch3_branch_incompatible_terminals(p, n);
    inout p, n;
    electrical p, n;
    electrical elec;
    rotational shaft;
    branch (elec, shaft) mismatched;

    analog begin
        I(p, n) <+ V(p, n);
    end
endmodule
