// §3.4.1: "No conversion shall be applied for strings; it shall be an error to
// assign a numeric value to a parameter declared as string or to assign a
// string value to a real parameter ..."
//
// This file is the first half: a numeric initializer on a parameter DECLARED
// string. The contrast is the sentence immediately before it — "If the type of
// the parameter is specified as integer or real, and the value assigned to the
// parameter conflicts with the type of the parameter, the value is converted to
// the type of the parameter" — which is why parameter_types.va's `parameter
// real size = 10` is legal. String is the type that does NOT get that
// conversion, and nothing else in the chapter says so.
//
// real_parameter_from_string.va is the other half.
//
//! lrm 3.4.1
//! lrm 3.4.1:2
//! reject-only E0345
//! neighbour parameter_types.va
`include "disciplines.vams"
module ch3_string_parameter_from_numeric(p, n);
    inout p, n;
    electrical p, n;
    parameter string device_type = 42;

    analog begin
        I(p, n) <+ V(p, n);
    end
endmodule
