// VerA's `vera_scratch` attribute (§2.9) with a value the model card decides.
//
// §2.9: `attr_spec ::= attr_name [ = constant_expression ]`. A parameter IS a
// constant expression, but the answer decides whether the device keeps a slot
// for the variable, before any model card exists, so the value must fold
// without one. E0534 names that. The legal neighbours, a bare
// `(* vera_scratch *)` and `(* vera_scratch = 0 *)`, are in
// vera_scratch_starts_each_evaluation.va.
//! lrm 2.9
//! reject-only E0534
//! neighbour vera_scratch_starts_each_evaluation.va
`include "disciplines.vams"
module reject_vera_scratch_parameter_value(p, n);
  inout p, n; electrical p, n;
  parameter integer on = 1;
  integer k;
  (* vera_scratch = on *) real st[0:3];
  analog begin
    k = ($abstime < 0.5) ? 1 : 2;
    st[k] = V(p, n);
    I(p, n) <+ st[1];
  end
endmodule
