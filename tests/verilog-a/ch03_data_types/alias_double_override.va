// §3.4.7, rule 4: "When overriding parameters, it shall be an error to specify
// an override for a parameter by its original name and one or more aliases, or
// by more than one alias, regardless of how the override is done (by name or
// using the defparam statement)."
//
// This is the LRM's own worked error, with its own declarations:
//
//     parameter real dtemp = 0 from [-`P_CELSIUS0:inf);
//     aliasparam trise = dtemp;
//     ...
//     nmos2 #(.trise(5), .dtemp(5)) m3(...);  //error
//
// "because an override is specified for the parameter dtemp and its alias, even
// though the values are equal." The equal values are the point: this is not a
// conflicting-value check that a compiler could discharge by comparing the two
// operands, it is a check on how many names one storage location was written
// through. parameter_alias.va is the legal side — one override, through the
// alias — and alias_identifier_collision.va is the other §3.4.7 negative,
// which is about the alias NAME rather than about an override.
//
// It is written as an instantiation because that is the only portable way to
// state an override in the source itself: the suite's `//! param` directive is
// consumed by the testbench generator and never reaches the compiler, so on a
// reject fixture it would assert nothing. Annex C.8 keeps Clause 6 hierarchy in
// the Verilog-A subset, and implicit_nets.va already carries an instance for
// the same reason.
//
// Pin E0908, which diagnoses duplicate parameter/alias overrides, rather than
// accepting any unrelated diagnostic that happens to mention an alias.
//
//! lrm 3.4.7
//! lrm 3.4.7:4
//! lrm C.8
//! reject-only E0908
//! neighbour parameter_alias.va
//! neighbour implicit_nets.va
`include "disciplines.vams"
`include "constants.vams"
module ch3_alias_override_target(d, s);
    inout d, s;
    electrical d, s;
    parameter real dtemp = 0 from [-273.15:inf);
    aliasparam trise = dtemp;

    analog I(d, s) <+ dtemp * V(d, s);
endmodule

module ch3_alias_double_override(d, s);
    inout d, s;
    electrical d, s;

    ch3_alias_override_target #(.trise(5), .dtemp(5)) m3(.d(d), .s(s));

    analog I(d, s) <+ 0.0;
endmodule
