// §3.6.2.5 overriding a nature attribute from the discipline. The declaration
// below is the LRM's `ttl` example: "the keyword flow or potential, then the
// hierarchical separator . and the attribute name, and, finally, set all of this
// equal to (=) the new value (e.g., flow.abstol = 10u)" — the
// nature_attribute_override nonterminal of Syntax 3-5.
//
// Attribute access observes the specified override directly: flow.abstol is
// 10u rather than the base nature's 1u, while potential.abstol stays 100u.
// These are the declared attribute values, not a claim about which iteration
// the solver should accept. Reading only V(t1,t2) would also pass if a compiler
// silently dropped the override.
//
// 2.5 - 0.5 = 2.0 V, and the flow contribution is what forces the flow half of
// the discipline — the overridden one — to be resolved at all.
//
//! bias V(t1) = 2.5, V(t2) = 0.5
//! lrm 3.6.2.5
//! lrm 3.6.2.5:1000
//! checks 3
// Own base natures below: D.1's guard keeps annex D's out of check.vh's include.
`define DISCIPLINES_VAMS 1
`include "check.vh"
nature ch03_override_voltage;
    units = "V";
    access = V;
    abstol = 100u;
endnature

nature ch03_override_current;
    units = "A";
    access = I;
    abstol = 1u;
endnature

discipline ch03_override_discipline;
    potential ch03_override_voltage;
    flow ch03_override_current;
    flow.abstol = 10u;
enddiscipline

module ch03_discipline_override(t1, t2);
    inout t1, t2;
    ch03_override_discipline t1, t2;

    analog begin
        `CHECKX("a net of a discipline that overrides flow.abstol still reads with its potential access function", V(t1, t2), 2.0);
        `CHECKX("the flow nature receives the discipline's override", t1.flow.abstol, 1e-5);
        `CHECKX("the override leaves the potential tolerance unchanged", t1.potential.abstol, 1e-4);
        I(t1, t2) <+ 0.5 * V(t1, t2);
    end
endmodule
