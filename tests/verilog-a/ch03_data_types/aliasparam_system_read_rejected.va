// §3.4.7's system-parameter alias example has the same equation-use rule.
// The alias m cannot be read in an equation. ch09_system_tasks/
// aliasparam_mfactor.va is the corrected legal neighbour: the host binds
// m, and the equations read $mfactor. This pins its withdrawn acceptance claim.
//! lrm 3.4.7
//! lrm 3.4.7:3
//! reject-only E0373
`include "disciplines.vams"
module aliasparam_system_read(p);
  inout p; electrical p;
  aliasparam m=$mfactor;
  analog I(p) <+ m+V(p);
endmodule
