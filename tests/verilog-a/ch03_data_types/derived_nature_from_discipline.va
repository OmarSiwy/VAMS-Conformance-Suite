// §3.6.2.6 deriving a nature from a discipline: "A nature can be derived from
// the nature bound to the potential or flow in a discipline ... the nature
// declaration shall also include the discipline name followed by the
// hierarchical separator (.) and the keyword flow or potential". The LRM's own
// pair is reproduced verbatim below, including the comments:
//
//     nature ttl_net_curr : ttl.flow;   // abstol = 10u as modified in ttl
//     nature ttl_net_volt : ttl.potential;
//        abstol = 1m; maxval = 12.3;
//
// The file this replaces derived from `ch03_base.potential` where no discipline
// `ch03_base` was ever declared, so the parent had none of the three attributes
// §3.6.1.2 requires; it also had no ports and no analog block, so it asserted
// nothing.
//
// The observable §3.6.2.6 fixes is INHERITANCE of the parent's `access`: nothing
// in `ch03_ttl_net_volt` says `access = V`, that name arrives through
// `ch03_ttl.potential` from `ch03_ttl_volt`, and it is the only spelling that can
// read a net of `ch03_ttl_net`. §3.6.1.2 makes access inheritance mandatory —
// "the derived nature always inherits the access attribute of its parent
// nature" — so a compiler that dropped the derivation cannot name the function.
// 4.0 - 1.0 = 3.0 V from the biases below.
// The inherited flow tolerance must be the discipline's overridden 10u,
// rather than the base nature's 1u. The derived potential retains its own 1m
// override and its user attribute maxval=12.3. These checks observe the
// attribute inheritance separately from the inherited access function.
//
//! bias V(dp) = 4.0, V(dn) = 1.0
//! lrm 3.6.2.6
//! lrm 3.6.1.2
//! lrm 3.6.1:1
//! lrm 3.6.2.6:1
//! lrm 3.6.2.6:2
//! checks 4
// Own base natures below: D.1's guard keeps annex D's out of check.vh's include.
`define DISCIPLINES_VAMS 1
`include "check.vh"
nature ch03_ttl_volt;
    units = "V";
    access = V;
    abstol = 100u;
endnature

nature ch03_ttl_curr;
    units = "A";
    access = I;
    abstol = 1u;
endnature

discipline ch03_ttl;
    potential ch03_ttl_volt;
    flow ch03_ttl_curr;
    flow.abstol = 10u;
enddiscipline

nature ch03_ttl_net_curr : ch03_ttl.flow;
endnature

nature ch03_ttl_net_volt : ch03_ttl.potential;
    abstol = 1m;
    maxval = 12.3;
endnature

discipline ch03_ttl_net;
    domain continuous;
    potential ch03_ttl_net_volt;
    flow ch03_ttl_net_curr;
enddiscipline

module ch03_derived_nature_from_discipline(dp, dn);
    inout dp, dn;
    ch03_ttl_net dp, dn;

    analog begin
        `CHECKX("a nature derived from <discipline>.potential inherits its access function", V(dp, dn), 3.0);
        `CHECKX("deriving from the discipline inherits its overridden flow tolerance", dp.flow.abstol, 1e-5);
        `CHECKX("the derived potential nature retains its own tolerance override", dp.potential.abstol, 0.001);
        `CHECKX("the derived potential nature retains its user attribute", dp.potential.maxval, 12.3);
        I(dp, dn) <+ 0.001 * V(dp, dn);
    end
endmodule
