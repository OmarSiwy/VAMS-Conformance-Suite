// §3.4.2, on its own `gain` example: "the default value for gain is 1 and it is
// allowed to acquire values within the range of 1 <= gain <= 1000." 2000 is
// above that closed upper bound, so the override must be diagnosed. The bound
// here is FINITE, unlike `[0:inf)` in the siblings — an implementation that only
// checked lower bounds, or that treated every upper bound as infinite, passes
// every other file in this family and fails this one.
//
// The override is written as an INSTANTIATION. §3.4.2 says "Range checking
// applies to the value of the parameter for the instance and not against the
// default values specified in the device", so the default 1 is legal and only
// an override can state this rule — and it cannot be the suite's `//! param`
// directive: that is consumed by the testbench generator, which never runs on a
// reject fixture, so the compiler would be handed the legal default alone and
// the fixture would demand a diagnostic no conforming compiler can emit.
// alias_double_override.va makes the same move for the same reason, and
// Annex C.8 keeps Clause 6 hierarchy in the Verilog-A subset.
//
// The pin used to be the message fragment `range`, because VerA had no
// range-checking diagnostic and so no code to name. E0361 is that code now: the
// value half of §3.4.2, raised on a parameter whose value came from a §6.3
// instance override, which is the only way a value ever reaches a declared range.
// Note also that §3.4.2 puts the error at SIMULATION time; a compiler that aborted
// the run instead of diagnosing the elaborated instance would need the runner
// taught about that verdict.
//
//! lrm 3.4.2
//! lrm C.8
//! lrm 3.4.2:2
//! reject-only E0361
`include "disciplines.vams"
module ch3_range_target_upper(p, n);
    inout p, n;
    electrical p, n;
    parameter real gain = 1 from [1:1000];

    analog I(p, n) <+ gain * V(p, n);
endmodule

module ch03_parameter_range_above_inclusive_upper(p, n);
    inout p, n;
    electrical p, n;

    ch3_range_target_upper #(.gain(2000)) upper(.p(p), .n(n));

    analog I(p, n) <+ 0.0;
endmodule
