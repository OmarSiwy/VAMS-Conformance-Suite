// §3.5, second half of the same sentence pair: "Assignments to the genvar
// variable i can consist only of expressions of static values, e.g.,
// parameters, literals, and other genvar variables."
//
// The step `index = index + V(p, n)` IS in the for-loop control, so it satisfies
// the first half of §3.5 — genvar_assigned_outside_loop.va is that half. What
// it is not is static: `V(p, n)` is a solution-dependent probe, so the trip
// count is not known at elaboration and the loop cannot be unrolled, which is
// the whole reason §3.5 exists (§5.9.3 analog_for).
//
// Replacing `V(p, n)` with `1`, or with a parameter, makes the file legal.
//
//! lrm 3.5
//! lrm 3.5:1000
//! reject-only E0419
//! neighbour genvar_static_dependencies.va
`include "disciplines.vams"
module ch3_genvar_nonstatic_loop_control(p, n);
    inout p, n;
    electrical p, n;
    genvar index;
    real acc;

    analog begin
        acc = 0.0;
        for (index = 0; index < 3; index = index + V(p, n)) begin
            acc = acc + 1.0;
        end
        I(p, n) <+ acc * V(p, n);
    end
endmodule
