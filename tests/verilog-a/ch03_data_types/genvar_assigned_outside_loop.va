// §3.5: "The genvar variable i can only be assigned within the for-loop
// control."
//
// `index` is assigned by a plain statement in the analog block, with no for
// loop anywhere in the file. genvar.va is the legal side: the same genvar,
// assigned only in the initialization and iteration slots of
// `for (index = 0; index < 3; index = index
// + 1)`.
//
// Without this file a genvar is indistinguishable from an integer — 09_genvar
// passes unchanged if `genvar index;` is rewritten `integer index;` — so this
// is the fixture that makes the type mean something.
//
// Pin the E0313 at the illegal assignment target, not a generic failed phase.
// The current diagnostic describes namespace lookup rather than the genvar
// restriction. If a dedicated rule diagnostic replaces it, verify that change
// against this source instead of accepting arbitrary compilation failures.
//
//! lrm 3.5
//! lrm 3.5:1000
//! lrm 6.6.1
//! lrm 6.6.1:2
//! reject-only E0313
//! neighbour genvar.va
`include "disciplines.vams"
module ch3_genvar_assigned_outside_loop(p, n);
    inout p, n;
    electrical p, n;
    genvar index;

    analog begin
        index = 3;
        I(p, n) <+ 0.0;
    end
endmodule
