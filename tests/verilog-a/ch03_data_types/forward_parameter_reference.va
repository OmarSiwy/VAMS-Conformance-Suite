// §3.4: "the right hand side of the assignment, called the initializer, shall
// be a constant expression, that is, an expression containing only constant
// numbers and PREVIOUSLY DEFINED parameters."
//
// `slope` is initialized from `offset`, which is declared on the next line, so
// `offset` is not previously defined at the point of use. Swapping the two
// declarations makes the file legal, which is the whole defect: the expression
// is otherwise a constant expression of exactly the permitted shape.
//
// This is the half a compiler misses when it resolves parameters in two passes
// and never checks declaration order.
//
//! lrm 3.4
//! lrm 3.4:1
//! reject-only E0314
`include "disciplines.vams"
module ch3_forward_parameter_reference(p, n);
    inout p, n;
    electrical p, n;
    parameter real slope = offset;
    parameter real offset = 1.0;

    analog begin
        I(p, n) <+ slope * V(p, n);
    end
endmodule
