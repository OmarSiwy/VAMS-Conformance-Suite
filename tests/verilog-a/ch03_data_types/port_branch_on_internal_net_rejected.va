// §3.12.1: "A port branch is a special type of branch used to access the flow
// into a port of a module (see 5.4.3). It is a branch between the upper and
// lower connections of the port." Syntax 3-9 names what goes between the angle
// brackets:
//
//     port_branch_declaration ::= branch ( < port_identifier > ) list_of_branch_identifiers ;
//
// `mid` is declared `electrical` inside the module and is not in its port list:
// it has no upper connection (nothing outside the module is joined to it), so
// there is no "upper and lower connections of the port" for the branch to lie
// between, and `mid` is not a port_identifier. With `branch (<p>) probe;` — p
// IS a port — the same module compiles (checked by hand when this fixture was
// written); port_branch.va is that legal form, run and asserted.
//
//! lrm 3.12.1
//! lrm 3.12.1:1000
//! reject-only E0372
//! neighbour port_branch.va
`include "disciplines.vams"
module ch3_port_branch_on_internal_net(p);
    inout p;
    electrical p;
    electrical mid;
    branch (<mid>) probe;

    analog begin
        I(p, mid) <+ V(p, mid) / 1000.0;
        I(mid) <+ V(mid) / 1000.0;
    end
endmodule
