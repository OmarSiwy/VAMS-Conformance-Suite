// §3.4.2: "Brackets, [ and ], indicate inclusion of the end points in the value
// range. ... The FIRST expression in the range shall be numerically smaller
// than the second expression in the range."
//
// `from [10:1]` writes them the other way round, which describes the empty set:
// no value is both >= 10 and <= 1, so the parameter could never take a legal
// value and its own default of 5 is outside its own range. Writing `from [1:10]`
// makes the file legal and 5 is then inside it.
//
// This is decidable from the declaration alone, with no instance value, which is
// what separates it from the 45_parameter_range_* family: those exercise an
// instance value against a declared range, while this declaration's bound
// ordering is malformed independently of the chosen instance value.
//
// E0347 identifies the malformed bound order, not an arbitrary earlier failure.
//
//! lrm 3.4.2
//! lrm 3.4.2:1
//! reject-only E0347
//! neighbour parameter_ranges.va
`include "disciplines.vams"
module ch3_range_first_expression_larger(p, n);
    inout p, n;
    electrical p, n;
    parameter real gain = 5 from [10:1];

    analog begin
        I(p, n) <+ gain * V(p, n);
    end
endmodule
