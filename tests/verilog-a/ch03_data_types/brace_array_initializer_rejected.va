// §3.4: "For parameters defined as arrays, the initializer shall be a
// constant_assignment_pattern expression ... using an assignment pattern (see
// 4.2.14), i.e. within '{ and } delimiters."
//
// `coeffs` is declared as a parameter array but its initializer is a plain
// brace list, `{2.1, 4.5}`. Without the apostrophe that is §4.2.13's
// concatenation operator, not §4.2.14's assignment pattern, so it is not an
// initializer an array parameter may take. The same declaration with `'{` is
// parameter_array.va, which runs and reads the elements back.
//
// Annex G Table G.4 item 2 records exactly this change: "Add apostrophe before
// opening { in list of values (to distinguish a list of values from the
// concatenation operator)". E0349 is VerA's code for the missing pattern.
//
//! lrm 3.4
//! lrm 3.4:2
//! lrm 4.2.14
//! lrm G.1
//! reject-only E0349
//! neighbour parameter_array.va
`include "disciplines.vams"
module ch03_brace_array_initializer(p, n);
    inout p, n;
    electrical p, n;
    parameter real coeffs[0:1] = {2.1, 4.5};

    analog I(p, n) <+ V(p, n);
endmodule
