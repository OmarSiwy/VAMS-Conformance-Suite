// §3.13.4: "The scope rules for branch identifiers are the same as the scope
// rules for net identifiers. A branch can only be declared inside a module
// scope; a branch can not be declared local to a block."
//
// `inner` is declared inside the named analog block `blk`. The same declaration
// at module scope is named_branches.va, which compiles and runs.
//
// This is a separate file from net_local_to_block.va although the sentence
// is word for word the same one: a net declaration and a branch declaration are
// different productions (A.2.1.3 `net_declaration` against A.2.1.3
// `branch_declaration`), so a compiler can plausibly place one correctly and
// not the other.
//
// E0209 is the current parser rejection at the forbidden branch keyword, not
// a dedicated scope diagnostic. A future scope-specific replacement needs
// review, rather than silently accepting an arbitrary failed phase.
//
//! lrm 3.13.4
//! lrm 3.13.4:1000
//! reject-only E0209
//! neighbour named_branches.va
`include "disciplines.vams"
module ch3_branch_local_to_block(p, n);
    inout p, n;
    electrical p, n;

    analog begin : blk
        branch (p, n) inner;
        I(p, n) <+ V(p, n);
    end
endmodule
