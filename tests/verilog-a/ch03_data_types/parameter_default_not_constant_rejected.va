// §3.4 / A.2.4: a parameter assignment is
//
//     param_assignment ::= parameter_identifier = constant_mintypmax_expression
//
// and §3.4's own prose fixes what "constant" buys: "The default_value may not
// be changed at runtime" — a parameter is set per instance (§6.3) and then
// FIXED for the solve. `$abstime` is the opposite of that: §9.10 defines it as
// the current simulation time, a different value at every accepted point, so a
// default reading it has no single number a model card could carry.
//
// parameter_default_over_parameter.va is the legal half of the same
// production — a default over another PARAMETER survives as an expression the
// override machinery re-evaluates (§6.3.4) — and it must keep compiling; the
// constancy check is about the operating point, not about "did it fold".
//
// This file exists because the illegal default used to compile silently: the
// `$abstime` vanished and the emitted model card read `bad = 0.0`, which is
// indistinguishable from a model whose author meant zero.
//
//! lrm 3.4
//! lrm A.2.4
//! lrm 3.4:1
//! lrm A.2.4:1000
//! reject-only E0363
//! neighbour parameter_default_over_parameter.va
`include "disciplines.vams"
module ch03_parameter_default_not_constant(p, n);
    inout p, n;
    electrical p, n;
    parameter real bad = $abstime;

    analog begin
        I(p, n) <+ V(p, n) * bad;
    end
endmodule
