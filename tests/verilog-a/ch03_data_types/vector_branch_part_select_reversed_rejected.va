// A branch terminal's part-select reads in the vector's declared direction:
// IEEE 1364-2005 §5.2.1 (inherited through §1.1) on `vect[msb_expr:lsb_expr]`,
// "The first expression has to address a more significant bit than the second
// expression." On `electrical [3:0] a`, bit 3 is the most significant, so
// `a[2:1]` is a part and `a[1:2]` is not. VerA refuses the reversed select
// with E0352, naming the declaration.
// The neighbour selects a[2:1] and the indexed parts a[0 +: 2], a[3 -: 2].
//
//! lrm A.2.1.3
//! lrm 3.12
//! reject-only E0352
//! reject is not a part of it
//! neighbour vector_branch_on_part_select.va
`include "disciplines.vams"
module vector_branch_part_select_reversed(a, z);
    inout [3:0] a;
    inout z;
    electrical [3:0] a;
    electrical z;
    branch (a[1:2], z) bad;    // illegal: [1:2] reverses the declared [3:0]

    analog I(a[0], z) <+ V(a[0], z);
endmodule
