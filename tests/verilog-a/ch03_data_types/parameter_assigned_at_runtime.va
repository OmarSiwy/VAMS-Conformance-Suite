// §3.4: "Parameters represent constants, hence it is illegal to modify their
// value at runtime."
//
// This is the one sentence that makes `parameter real gain` different from
// `real gain`, and it is the only place the difference shows: everything else
// in the chapter reads parameters, which a plain variable would satisfy too.
// The identical assignment to the `scratch` variable beside it is legal and is
// left in the file, so a compiler that rejected all assignment in an analog
// block would not pass this either.
//
// §3.4 goes on to allow the value to be changed at COMPILATION time —
// "parameters can be modified with the defparam statement or in the
// module_instantiation statement" — and local_parameter.va is that legal
// direction, through the harness's `//! param` override.
//
//! lrm 3.4
//! lrm 3.4:3
//! reject-only E0312
//! neighbour local_parameter.va
`include "disciplines.vams"
module ch3_parameter_assigned_at_runtime(p, n);
    inout p, n;
    electrical p, n;
    parameter real gain = 2.0;
    real scratch;

    analog begin
        scratch = 3.0;
        gain = 3.0;
        I(p, n) <+ gain * scratch * V(p, n);
    end
endmodule
