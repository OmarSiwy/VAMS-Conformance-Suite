// Resolved semantic behavior is observed by tests/host.py.
// §3.6.2.7: "Like natures, a discipline can specify user-defined attributes."
// A discipline declares a custom attribute `max_voltage` with a constant value,
// demonstrating that discipline declarations accept user-defined attributes.
//
// THE LRM CONTRADICTS ITSELF HERE, and this fixture records the reading VerA
// commits to. §3.6.2.7's sentence above is explicit; A.1.7's discipline_item
// gives exactly three productions — nature_binding, discipline_domain_binding,
// nature_attribute_override (`potential.abstol = ...`) — and none of them
// admits a bare `attr = value;`. DECISION: the prose governs, and A.1.7 is
// treated as a non-exhaustive erratum. §3.6.2.7 exists for a reason — real
// designs and vendor tools hang user attributes off disciplines just as they do
// off natures — while the annex's omission asserts nothing (an incomplete
// grammar is the commonest kind of erratum). The attribute is stored on the
// declaration exactly as a nature's user attributes are (`DisciplineDecl.attrs`
// mirrors `NatureDecl.attrs`); no LRM syntax READS one back — §5.5.3's
// `net.potential.attr` lands on the bound nature's table — so declaring it and
// using the discipline is the whole observable rule, and V(p,n) proves the
// module built.
//
//! bias V(p) = 1.0
//! lrm A.1.7
//! lrm 3.6.2.7:1000
// Own base natures below: D.1's guard keeps annex D's out of check.vh's include.
`define DISCIPLINES_VAMS 1
`include "check.vh"

nature ch3267_voltage;
    units = "V";
    access = V;
    abstol = 1u;
endnature

nature ch3267_current;
    units = "A";
    access = I;
    abstol = 1p;
endnature

discipline ch3267_with_attr;
    potential ch3267_voltage;
    flow ch3267_current;
    max_voltage = 48.0;
enddiscipline

module ch3267_discipline_user_attribute(p, n);
    inout p, n;
    ch3267_with_attr p, n;

    analog begin
        `CHECKX("a discipline with a user-defined attribute can be declared and used", V(p, n), 1.0);
        I(p, n) <+ V(p, n) / 1000.0;
    end
endmodule
