// VerA's `vera_scratch` attribute (§2.9) on a net declaration.
//
// The attribute says a variable (§3.2) starts every evaluation afresh. A net
// (§3.6) holds no value an evaluation assigns: its potential is an unknown the
// host solves for. E0535 names that. The legal neighbour, the same attribute
// on a variable declaration, is in vera_scratch_starts_each_evaluation.va.
//! lrm 2.9
//! reject-only E0535
//! neighbour vera_scratch_starts_each_evaluation.va
`include "disciplines.vams"
module reject_vera_scratch_on_net(p, n);
  inout p, n; electrical p, n;
  (* vera_scratch *) electrical m;
  analog begin
    I(p, m) <+ V(p, m) / 1k;
    I(m, n) <+ V(m, n) / 1k;
  end
endmodule
