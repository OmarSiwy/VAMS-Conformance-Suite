// §3.6.2.5: "A discipline can override the value of the bound nature for the
// pre-defined attributes ... To do so from a discipline declaration, the bound
// nature and attribute needs to be defined ... the keyword flow or potential,
// then the hierarchical separator . and the attribute name, and, finally, set
// all of this equal to (=) the new value (e.g., flow.abstol = 10u)."
//
// The natures and the discipline are the clause's own `ttl` example (renamed).
// discipline_override.va declares the same override and asserts only that
// the nets still read; it never reads the attribute the override changed.
// §5.5.3 does: `net.flow.abstol` is "the abstol attribute of the flow nature of
// the net", and the net's flow nature is the one the discipline binds, with the
// discipline's override applied.
//
// DERIVATION.
//   t1.flow.abstol       the bound nature says 1u, the discipline says 10u:
//                        the override is the value, 10u = 1e-5
//   t1.potential.abstol  no override: the nature's own 100u = 1e-4
// The wants are written 1e-5 and 1e-4: §2.6.2 makes 10u and 1e-5 the same real
// number, and one decimal value parses to one binary64, so CHECKX is exact.
//
//! lrm 3.6.2.5
//! lrm 3.6.2.5:1000
//! lrm 5.5.3
//! bias V(t1) = 2.5, V(t2) = 0.5
//! checks 3
// Own base natures below: D.1's guard keeps annex D's out of check.vh's include.
`define DISCIPLINES_VAMS 1
`include "check.vh"
nature b1_ttl_curr;
    units = "A";
    access = I;
    abstol = 1u;
endnature

nature b1_ttl_volt;
    units = "V";
    access = V;
    abstol = 100u;
endnature

discipline b1_ttl;
    potential b1_ttl_volt;
    flow b1_ttl_curr;
    flow.abstol = 10u;
enddiscipline

module b1_discipline_overrides_flow_abstol(t1, t2);
    inout t1, t2;
    b1_ttl t1, t2;

    analog begin
        `CHECKX("the discipline's flow.abstol overrides the bound nature's", t1.flow.abstol, 1e-5);
        `CHECKX("the potential nature keeps its own abstol", t1.potential.abstol, 1e-4);
        `CHECKX("the nets still read through the bound access", V(t1, t2), 2.0);
        I(t1, t2) <+ 0.5 * V(t1, t2);
    end
endmodule
