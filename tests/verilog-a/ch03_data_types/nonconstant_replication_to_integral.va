// §3.3's worked example, verbatim, with `r` a `reg [15:0]`, `a` and `b` strings
// and `i` an integer variable set to 1:
//
//     b = {5{"Hi"}};     // OK
//     a = {i{"Hi"}};     // OK (non constant replication)
//     r = {i{"Hi"}};     // invalid (non constant replication)
//
// The rule is NOT that a replication count must be constant — Table 3-3 says the
// opposite of the multiplier: it "must be of integral type and can be
// nonconstant". The rule is narrower: a nonconstant multiplier makes the result
// a string of N copies with no width known at elaboration, and a value with no
// width cannot be assigned to an INTEGRAL type. The same expression into a
// string is legal, which is the line above it. `packed_value` here is an
// `integer`, so this is the third line.
//
// string_replication.va is the legal side with a constant count into a
// string; the discriminating legal case for THIS rule is the second line above,
// a nonconstant count into a string.
//
// The pin used to be the phase label alone, because VerA rejected the line at
// E0207 — its expression parser had no replication form at all, constant or not
// — and pinning that code would have pinned the absence of the construct rather
// than the multiplier. Replication has landed, so the day this file was written
// for has arrived: the code is E0354, §3.3's own "a string cannot be assigned to
// an integral type", reached because Table 3-3 makes this replication a string.
//
//! lrm 3.3
//! reject-only E0354
//! neighbour string_replication.va
`include "disciplines.vams"
module ch3_nonconstant_replication_to_integral(p, n);
    inout p, n;
    electrical p, n;
    integer count = 1;
    integer packed_value;

    analog begin
        packed_value = {count{"Hi"}};
        I(p, n) <+ packed_value * V(p, n);
    end
endmodule
