// §3.6: "A net is characterized by the discipline it follows. ... Therefore,
// a net is always declared as a type of discipline. In this sense, a
// discipline is a user-defined type for declaring a net." Syntax 3-6 says the
// same in grammar: `net_declaration ::= ... | discipline_identifier [ range ]
// list_of_net_identifiers ;`.
//
// `Voltage` is annex D's NATURE (units "V", access V), not a discipline. §3.6's
// next sentence says what a discipline adds that a nature does not: "A
// discipline is characterized by the domain and the attributes defined in the
// natures for potential and flow" — a nature alone binds neither a domain nor
// a potential/flow role, so `Voltage n1;` declares a net with no discipline to
// follow. Natures and disciplines share one namespace (§3.13.1), so the name
// cannot be read as some other discipline of the same spelling.
//
// With `electrical n1;` the same module compiles (checked by hand when this
// fixture was written); the defect is the one type name.
//
//! lrm 3.6
//! lrm 3.6.3
//! lrm 3.6:1000
//! reject-only E0371
//! neighbour scalar_nets.va
`include "disciplines.vams"
module ch3_net_declared_with_nature_name(p, n);
    inout p, n;
    electrical p, n;
    Voltage n1;

    analog begin
        I(p, n) <+ V(p, n) * 1.0e-3;
    end
endmodule
