// §3.3 Table 3-3's equality: "Both strings can be of type string, or one of
// them can be a string literal which is implicitly converted to a string type
// for the comparison." `s == 65` compares a string variable with an integer,
// which is neither form, and "A string cannot be assigned to an integral
// type" leaves no conversion to make the integer one. Refused as a string
// operand where a number is required (E0321).
//
// The legal neighbour compares the literal "A" with 65, a Verilog integer
// equality (§3.3: string literals "behave exactly the same as in Verilog"):
// string_literal_operand_is_a_number.va.
//
//! lrm 3.3
//! reject-only E0321
//! neighbour string_literal_operand_is_a_number.va
`include "disciplines.vams"
module string_variable_compared_with_number_rejected(p, n);
  inout p, n; electrical p, n;
  string s = "A";
  integer k;
  analog begin
    k = (s == 65);
    I(p, n) <+ V(p, n);
  end
endmodule
