// §3.4.7 says the alias identifier shall not occur elsewhere in the module.
// A constant-false branch does not legalize the expression. The check must
// precede constant folding and dead-branch elimination. The legal original
// spelling and legitimate alias bindings run in aliasparam_source_bindings.va.
//! lrm 3.4.7
//! lrm 3.4.7:3
//! reject-only E0373
//! neighbour aliasparam_source_bindings.va
`include "disciplines.vams"
module aliasparam_dead_read(p);
  inout p; electrical p;
  parameter real gain=1;
  aliasparam alternate=gain;
  analog if (0) I(p) <+ alternate*V(p);
endmodule
