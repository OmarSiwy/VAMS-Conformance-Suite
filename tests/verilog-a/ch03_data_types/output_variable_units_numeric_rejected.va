// §3.2.1: "The standard attributes for descriptions and units, described in
// 2.9.2, have a special meaning for variables declared at module scope. Module
// scope variables with a description or units attribute, or both, shall be
// known as output variables". The attributes that make an output variable are
// §2.9.2's, whose units row says: "The units attribute is used to describe the
// units of the parameter or variable which it is attached to within a module.
// The attribute must be assigned a string."
//
// `cgs` is a module-scope variable — the would-be output variable of §3.2.1's
// own example — whose units attribute is the real constant 1.0e-15 rather
// than a string. That is the only defect: with `units = "F"` the declaration is
// output_variable_description_and_units.va's, and compiles (checked by hand when this fixture was written).
//
//! lrm 3.2.1
//! lrm 2.9.2
//! lrm 2.9.2:1
//! lrm 2.9.2:2
//! reject-only E0358
//! neighbour output_variable_description_and_units.va
`include "disciplines.vams"
module ch3_output_variable_units_numeric(p, n);
    inout p, n;
    electrical p, n;
    (* desc = "gate-source capacitance", units = 1.0e-15 *) real cgs;
    analog begin
        cgs = 4.21e-15;
        I(p, n) <+ cgs * V(p, n);
    end
endmodule
