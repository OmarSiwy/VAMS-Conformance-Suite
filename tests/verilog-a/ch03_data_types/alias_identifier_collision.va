// §3.4.7, rule 2: "The alias_identifier shall not occur anywhere else in the
// module; in particular, it shall not conflict with a different
// parameter_identifier ..."
//
// `trise` is declared as a parameter in its own right and then reused as the
// alias of `dtemp`. An aliasparam gives an existing parameter a second NAME; it
// does not declare a second parameter, so with both declarations present
// `trise` has two distinct storage locations and an override by that name has no
// unique meaning. Deleting either line makes the file legal.
//
// parameter_alias.va is the legal side, with the alias naming nothing else.
//
//! lrm 3.4.7
//! lrm 3.4.7:3
//! reject-only E0331
//! neighbour parameter_alias.va
`include "disciplines.vams"
module ch3_alias_identifier_collision(p, n);
    inout p, n;
    electrical p, n;
    parameter real dtemp = 0;
    parameter real trise = 1;
    aliasparam trise = dtemp;

    analog begin
        I(p, n) <+ dtemp * V(p, n);
    end
endmodule
