// §3.12: "If one of the terminals of a branch is a vector net, then the other
// terminal shall either be a scalar net or a vector net of the same size."
//
// `a` is size 4 and `b` is size 2, and neither is scalar, so there is no
// one-to-one pairing (Figure 3-1) and no vector-to-scalar fan-in (Figure 3-2)
// that this declaration could mean. It is an error.
//
// vector_branches.va is the legal side of the same rule: [3:5] against
// [1:3], both size 3.
//
// Pin E0353 at the mismatched declaration. No use of the invalid branch is
// needed: indexing it produced cascading E0351 errors, which a generic phase
// pin could mistake for validation of the terminal-size rule.
//
//! lrm 3.12
//! lrm 3.12:1001
//! reject-only E0353
//! neighbour vector_branches.va
`include "disciplines.vams"
module ch3_vector_branch_size_mismatch(a, b);
    inout a, b;
    electrical [3:0] a;
    electrical [1:0] b;
    branch (a, b) bad;

    analog begin
    end
endmodule
