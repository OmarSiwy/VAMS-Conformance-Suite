// §3.4.7 restricts an alias to binding: a §6.7 hierarchical expression
// must also name the original parameter. The root-qualified path cannot
// bypass that rule. aliasparam_source_bindings.va reads child.gain legally.
//! lrm 3.4.7
//! reject-only E0373
//! neighbour aliasparam_source_bindings.va
`include "disciplines.vams"
module aliasparam_hierarchical_top(p);
  inout p; electrical p;
  aliasparam_hierarchical_child #(.alternate(3)) child();
  analog I(p) <+ $root.aliasparam_hierarchical_top.child.alternate*V(p);
endmodule
module aliasparam_hierarchical_child;
  parameter real gain=1;
  aliasparam alternate=gain;
endmodule
