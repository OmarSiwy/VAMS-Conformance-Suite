// §3.2, of the range on an array declaration: "Both indices shall be constant
// expressions and shall evaluate to a positive integer, a negative integer, or
// zero (0)."
//
// `size` is a run-time integer variable, so `real vals[0:size]` has no size at
// elaboration. This reads almost the same in a diff as
// dynamic_array_index.va, and is the opposite verdict: that fixture indexes a
// legally-declared array with a run-time expression, which §3.2 says nothing
// against, while this one puts the run-time expression in the BOUND. Replacing
// `size` with a literal or a parameter makes the file legal
// (parameter_array.va does the parameter form).
//
//! lrm 3.2
//! lrm 3.2:1
//! lrm 3.2:2
//! reject E0308
//! neighbour parameter_array.va
//! neighbour dynamic_array_index.va
`include "disciplines.vams"
module ch3_nonconstant_array_dimension(p, n);
    inout p, n;
    electrical p, n;
    integer size;
    real vals[0:size];

    analog begin
        size = 2;
        vals[0] = 1.0;
        I(p, n) <+ vals[0] * V(p, n);
    end
endmodule
