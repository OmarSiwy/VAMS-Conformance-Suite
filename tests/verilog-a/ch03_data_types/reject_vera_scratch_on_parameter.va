// VerA's `vera_scratch` attribute (§2.9) on a parameter declaration.
//
// The attribute says a variable (§3.2) starts every evaluation afresh. §3.4:
// a parameter is a constant, so it holds no value an evaluation assigns and
// the attribute would mean nothing there. E0535 names that. The legal
// neighbour, the same attribute on a variable declaration, is in
// vera_scratch_starts_each_evaluation.va.
//! lrm 2.9
//! reject-only E0535
//! neighbour vera_scratch_starts_each_evaluation.va
`include "disciplines.vams"
module reject_vera_scratch_on_parameter(p, n);
  inout p, n; electrical p, n;
  (* vera_scratch *) parameter real g = 1m;
  analog I(p, n) <+ g * V(p, n);
endmodule
