// §3.3: "Verilog-AMS provides a set of operators that can be used to
// manipulate combinations of string variables and string literals. The basic
// operators defined on the string data type are listed in Table 3-3." Table
// 3-3 has no arithmetic operator, and §3.3 adds "A string cannot be assigned
// to an integral type". `s + 1` adds an integer to a string VARIABLE.
//
// string_arithmetic_rejected.va refuses the same sum on a string parameter.
// This variable is assigned a literal, so its value is a constant VerA can
// see: until 2026-10-08 that constant was read as the literal's bytes and the
// sum compiled to 66. The legal neighbour writes the literal itself, which
// §3.3 makes a Verilog number: string_literal_operand_is_a_number.va.
//
//! lrm 3.3
//! reject-only E0321
//! neighbour string_literal_operand_is_a_number.va
`include "disciplines.vams"
module string_variable_arithmetic_rejected(p, n);
  inout p, n; electrical p, n;
  string s = "A";
  integer k;
  analog begin
    k = s + 1;
    I(p, n) <+ V(p, n);
  end
endmodule
