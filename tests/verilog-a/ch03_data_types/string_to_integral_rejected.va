// §3.3: "A string literal can be assigned to a string or an integral type. ...
// A string or a string literal can be assigned directly to a string variable.
// A string cannot be assigned to an integral type."
//
// The distinction is literal-versus-variable and it is easy to get backwards.
// `integer code = "A";` is a string LITERAL into an integral type and is legal
// (string_literal_to_integral.va asserts what it produces); `code = label;`
// is a string VARIABLE into the same integral type and is the error. Both lines
// are in this file so the pair is on the page together, and the pin still cannot
// tell them apart on its own: a compiler that rejected string-to-integral
// wholesale would diagnose the legal line and satisfy this fixture just the
// same. string_literal_to_integral.va is where the discrimination lives — it
// asserts the VALUES the legal direction produces, so a compiler that refused it
// fails there.
//
// E0354 is VerA's code for the rule, and it is written on the distinction rather
// than on the types: `Lower.coerceTo` lets a `.str_literal` through and refuses
// every other string-typed expression, so `integer code = "A"` above is accepted
// here and it is 73 that says whether the value is right.
//
//! lrm 3.3
//! lrm 3.3:1001
//! reject-only E0354
//! neighbour string_literal_to_integral.va
`include "disciplines.vams"
module ch3_string_to_integral(p, n);
    inout p, n;
    electrical p, n;
    string label = "hi";
    integer code = "A";

    analog begin
        code = label;
        I(p, n) <+ code * V(p, n);
    end
endmodule
