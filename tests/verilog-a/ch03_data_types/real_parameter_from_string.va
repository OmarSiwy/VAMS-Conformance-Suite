// §3.4.1: "No conversion shall be applied for strings; it shall be an error ...
// to assign a string value to a real parameter, whether that parameter was
// declared as real or had its type derived from the type of the value of the
// constant expression."
//
// This file is the declared-real half: `parameter real gain = "hi"`. It is the
// mirror of string_parameter_from_numeric.va and a separate file because the
// two directions are separate checks — a compiler that coerces everything to
// real passes the string-parameter case and fails this one.
//
// The derived-type/override forms are not exercised by this fixture. Numeric
// `//! param` bindings cannot supply a string, but that harness limitation is
// not a language prohibition or evidence that source-level instance overrides
// are untestable. Those paths remain separate obligations in the parameter audit.
//
//! lrm 3.4.1
//! lrm 3.4.1:2
//! reject-only E0345
`include "disciplines.vams"
module ch3_real_parameter_from_string(p, n);
    inout p, n;
    electrical p, n;
    parameter real gain = "hi";

    analog begin
        I(p, n) <+ gain * V(p, n);
    end
endmodule
