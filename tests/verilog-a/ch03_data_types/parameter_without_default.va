// §3.4.1: "The parameter declaration can contain an optional type
// specification. In this sense, the parameter keyword acts more as a type
// qualifier than a type specifier. A default value for the parameter shall be
// specified."
//
// `gain` is declared with a type and no value. Syntax 3-2 says the same thing
// grammatically — `param_assignment ::= parameter_identifier =
// constant_mintypmax_expression` has no form without the `=` — so a conforming
// compiler cannot even parse this, which is why the expectation is the parse
// stage rather than a semantic check.
//
// Distinct from forward_parameter_reference.va and
// variable_in_parameter_initializer.va: those are about what the initializer
// may contain, this one is about its absence.
//
//! lrm 3.4.1
//! lrm 3.4.1:1
//! reject-only E0207
//! neighbour parameter_types.va
`include "disciplines.vams"
module ch3_parameter_without_default(p, n);
    inout p, n;
    electrical p, n;
    parameter real gain;

    analog begin
        I(p, n) <+ gain * V(p, n);
    end
endmodule
