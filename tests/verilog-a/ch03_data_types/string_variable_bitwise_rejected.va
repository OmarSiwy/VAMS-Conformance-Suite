// §3.3 Table 3-3 lists the operators "defined on the string data type", and
// no bitwise operator (§4.2.9) is among them; "A string cannot be assigned to
// an integral type" leaves no conversion to make one apply. `s & 1` with `s` a
// string variable is refused as a bitwise operator without integer operands
// (E0322).
//
// The legal neighbour applies `&` to the literal "A", which §3.3 makes the
// Verilog integer 65: string_literal_operand_is_a_number.va.
//
//! lrm 3.3
//! reject-only E0322
//! neighbour string_literal_operand_is_a_number.va
`include "disciplines.vams"
module string_variable_bitwise_rejected(p, n);
  inout p, n; electrical p, n;
  string s = "A";
  integer k;
  analog begin
    k = s & 1;
    I(p, n) <+ V(p, n);
  end
endmodule
