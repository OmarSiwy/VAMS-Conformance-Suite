// §3.6.3.2: "The initializer shall be a constant_expression and will be used
// as a nodeset value for the potential of the net by the analog solver." The
// hierarchical form is held to the same rule as a local one
// (nodeset_not_constant.va): `V(g)` is not a constant expression.
//
// Legal neighbour: nodeset_hierarchical_declaration.va.
//
//! lrm 3.6.3.2
//! reject-only E0365
//! neighbour nodeset_hierarchical_declaration.va
`include "disciplines.vams"
module ns_bad_child(g);
  inout g; electrical g;
  electrical w;
  analog I(w, g) <+ V(w, g);
endmodule
module ns_bad_top(g);
  inout g; electrical g;
  ns_bad_child u(g);
  electrical u.w = V(g);
endmodule
