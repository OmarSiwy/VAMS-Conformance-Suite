// §3.2, of the range on an array declaration: "Both indices shall be constant
// expressions and shall evaluate to a positive integer, a negative integer, or
// zero (0)."
//
// `size` is an integer variable, not a constant expression, so the second
// index of `vals[0:size]` has no value at elaboration and the array has no
// shape. The declaration is the whole defect: the array is never used, so
// there is exactly one diagnostic, at the bounds. parameter_array.va is
// the legal counterpart whose bound is a previously-declared parameter
// (§3.4.4), and nonconstant_array_dimension.va keeps the same bad bound
// together with uses of the array, which is why that file is a `reject` and
// this one can be `reject-only`.
//
// E0308 is "array bound is not a constant expression", raised at the
// declaration; the lowerer's own unit test pins the same shape with the same
// single code.
//
//! lrm 3.2
//! lrm 3.2:1
//! lrm 3.2:2
//! reject-only E0308
//! neighbour parameter_array.va
`include "disciplines.vams"
module ch03_array_bound_not_constant(p, n);
    inout p, n;
    electrical p, n;
    integer size;
    real vals[0:size];

    analog I(p, n) <+ V(p, n);
endmodule
