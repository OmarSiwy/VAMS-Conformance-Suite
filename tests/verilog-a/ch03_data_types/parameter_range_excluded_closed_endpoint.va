// §3.4.2: "Parentheses, ( and ), indicate exclusion of the end points from the
// value range. It is possible to include one end point and not the other using
// [ ) and ( ]." The second hole in the LRM's range is `exclude (30:40]`, whose
// upper end is CLOSED, so 40 is excluded and the override below is out of range.
// This is the endpoint that distinguishes `(30:40]` from `(30:40)`; its open
// twin, 30, is legal and is asserted in parameter_range_legal_endpoints.va.
// The declaration is §3.4.2's own worked example, verbatim.
//
// The override is written as an INSTANTIATION. §3.4.2 says "Range checking
// applies to the value of the parameter for the instance and not against the
// default values specified in the device", so the default 0 is legal and only
// an override can state this rule — and it cannot be the suite's `//! param`
// directive: that is consumed by the testbench generator, which never runs on a
// reject fixture, so the compiler would be handed the legal default alone and
// the fixture would demand a diagnostic no conforming compiler can emit.
// alias_double_override.va makes the same move for the same reason, and
// Annex C.8 keeps Clause 6 hierarchy in the Verilog-A subset.
//
// The pin used to be the message fragment `range`, because VerA had no
// range-checking diagnostic and so no code to name. E0361 is that code now: the
// value half of §3.4.2, raised on a parameter whose value came from a §6.3
// instance override, which is the only way a value ever reaches a declared range.
// Note also that §3.4.2 puts the error at SIMULATION time; a compiler that aborted
// the run instead of diagnosing the elaborated instance would need the runner
// taught about that verdict.
//
//! lrm 3.4.2
//! lrm C.8
//! lrm 3.4.2:2
//! lrm 3.4.2:1001
//! reject-only E0361
//! neighbour parameter_range_legal_endpoints.va
`include "disciplines.vams"
module ch3_range_target_endpoint(p, n);
    inout p, n;
    electrical p, n;
    parameter real val3 = 0 from [0:inf) exclude (10:20) exclude (30:40];

    analog I(p, n) <+ val3 * V(p, n);
endmodule

module ch03_parameter_range_excluded_closed_endpoint(p, n);
    inout p, n;
    electrical p, n;

    ch3_range_target_endpoint #(.val3(40)) endpoint(.p(p), .n(n));

    analog I(p, n) <+ 0.0;
endmodule
