// VerA's `vera_scratch` attribute (§2.9) with a string that names no mode.
//
// §2.9: `attr_spec ::= attr_name [ = constant_expression ]`, and a string is
// a constant expression. VerA reads a number (nonzero on, 0 off) or the one
// string "uninit"; any other string is a misspelling, which by §4.2's truth
// rule (a non-empty string is true) would otherwise silently mean plain
// scratch. E0538 names it. The legal neighbour, `= "uninit"`, is in
// vera_scratch_uninit_tape.va.
//! lrm 2.9
//! reject-only E0538
//! neighbour vera_scratch_uninit_tape.va
`include "disciplines.vams"
module reject_vera_scratch_unknown_string(p, n);
  inout p, n; electrical p, n;
  integer k;
  (* vera_scratch = "uninitialised" *) real st[0:3];
  analog begin
    k = ($abstime < 0.5) ? 1 : 2;
    st[k] = V(p, n);
    I(p, n) <+ st[k];
  end
endmodule
