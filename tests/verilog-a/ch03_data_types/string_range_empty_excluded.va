//! lrm 3.4.2
//! lrm 3.4.2:2
//! reject-only E0361
`include "disciplines.vams"
module string_range_empty_target(p);
    inout p;
    electrical p;
    parameter string filename = "result.dat" exclude '{""};
    analog I(p) <+ 0.0;
endmodule
module ch03_string_range_empty_excluded(p);
    inout p;
    electrical p;
    string_range_empty_target #(.filename("")) u(p);
endmodule
