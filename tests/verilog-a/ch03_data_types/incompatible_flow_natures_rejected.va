// AMS 3.11.1 Flow Incompatibility Rule: differing incompatible flow natures
// make disciplines incompatible even if their potential natures are identical.
// Both endpoints bind Voltage, so V is legal for each individually. The custom
// flow has units "s", unlike Current's "A", and shares no base nature with it.
//! lrm 3.11
//! lrm 3.11.1
//! lrm 3.11:1
//! lrm 3.11.1:2
//! reject-only E0355
`include "disciplines.vams"
nature audit_other_flow;
  units="s"; access=OtherFlow; abstol=1p;
endnature
discipline audit_bad_flow_disc;
  potential Voltage;
  flow audit_other_flow;
enddiscipline
module audit_incompatible_flow_natures_rejected(p);
  inout p;
  electrical p;
  audit_bad_flow_disc other;
  analog I(p) <+ V(p,other);
endmodule
