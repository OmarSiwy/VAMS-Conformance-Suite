// VerA's `vera_scratch` attribute (§2.9) on a variable whose value an event
// statement leaves for later evaluations.
//
// §5.10: an event statement runs only on the evaluations its event fires;
// `initial_step` (§5.10.2) fires on the first only. A value it assigns is
// therefore meant for the evaluations that do not run it: `k` is read below
// on every evaluation, and on all but the first only the held value can give
// 3. A scratch variable would read 0 there, so the attribute is refused with
// E0536 rather than silently changing what `k` reads. The legal neighbour is
// a scratch variable every evaluation assigns before reading, as in
// vera_scratch_starts_each_evaluation.va.
//! lrm 2.9
//! lrm 5.10
//! reject-only E0536
//! neighbour vera_scratch_starts_each_evaluation.va
`include "disciplines.vams"
module reject_vera_scratch_event_value(p, n);
  inout p, n; electrical p, n;
  (* vera_scratch *) real k;
  analog begin
    @(initial_step) k = 3.0;
    I(p, n) <+ k * V(p, n);
  end
endmodule
