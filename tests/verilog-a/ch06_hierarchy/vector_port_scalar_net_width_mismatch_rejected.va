// §6.5.7.1 "A scalar port can be connected to a scalar net and a vector port
// can be connected to a vector net or concatenated net expression of the
// matching width. The sizes of the ports and net must match."
//
// A 3-bit vector port connected to a scalar net: the sizes do not match. The
// child's body is empty on purpose, so nothing but the connection can be wrong
// — an earlier version indexed `port_vec[0]` and was refused for that (E0351)
// while the width went unchecked. Declaring the parent's net `electrical [2:0]`
// makes the file legal (vector_port_matching_net_width.va).
//
//! lrm 6.5.7.1
//! lrm 6.5.7.1:1
//! reject-only E0925
//! neighbour vector_port_matching_net_width.va
`include "disciplines.vams"
module ch6_port_net_size_mismatch_parent(p);
  inout p; electrical p;
  ch6_port_net_size_mismatch_child u(p);
endmodule

module ch6_port_net_size_mismatch_child(port_vec);
  inout [2:0] port_vec;
  electrical [2:0] port_vec;
  analog begin end
endmodule
