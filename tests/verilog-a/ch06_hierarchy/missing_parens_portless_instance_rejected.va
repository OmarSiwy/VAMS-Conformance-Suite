// §6.2.2: "The parentheses, however, are always required." The child is
// portless, so the connection list is empty — but it is still written as `()`.
// The instance below carries a parameter assignment and then stops:
// `ch6_mpp_child #(.unused(1.0)) u;` has no `(` after the instance name.
// Elaboration reports E0371 where the instance's connection list belongs; the
// `#(...)` is what makes the statement unambiguously an instance rather than a
// discipline's net declaration (the other production that starts
// `identifier identifier`), so the missing `()` is the whole defect.
//
// portless_instance_without_connections.va is the legal neighbour, the same
// instance spelled `u()`.
//
//! lrm 6.2.2
//! lrm 6.2.2:1001
//! reject-only E0207
//! neighbour portless_instance_without_connections.va
`include "disciplines.vams"
module ch6_mpp_top(p);
  inout p; electrical p;
  ch6_mpp_child #(.unused(1.0)) u;
endmodule

module ch6_mpp_child;
  parameter real unused = 0.0;
endmodule
