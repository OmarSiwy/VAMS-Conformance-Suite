// §6.4.2, selection rule 2: "The parameters of the paramset, with overrides
// and defaults, shall be all within the allowed ranges specified in the
// paramset parameter declaration."
//
// One paramset declares `l = 1.0 from [0.5:2.0]`; the instance overrides
// l = 3.0. The override is a parameter of the paramset (rule 1 passes), but
// 3.0 is outside [0.5:2.0], so rule 2 rejects the only candidate. No paramset
// named ch6_ppar_ps admits the instance and elaboration stops with E0911.
//
// The neighbour paramset_parameter_inside_range.va overrides l = 1.5 instead
// and is selected, which shows the refusal is the range and not the override.
//
//! lrm 6.4.2
//! lrm 6.4.2:4
//! reject-only E0911
//! neighbour paramset_parameter_inside_range.va
`include "disciplines.vams"
module ch6_ppar_top(p, n);
  inout p, n; electrical p, n;
  ch6_ppar_ps #(.l(3.0)) u(p, n);
endmodule

paramset ch6_ppar_ps ch6_ppar_dev;
  parameter real l = 1.0 from [0.5:2.0];
  .k = 2.0 * l;
endparamset

module ch6_ppar_dev(a, b);
  inout a, b; electrical a, b;
  parameter real k = 9.0;
  analog I(a, b) <+ k * V(a, b);
endmodule
