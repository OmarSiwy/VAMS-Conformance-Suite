// THIS REJECTION IS CORRECT CONFORMANCE, and the file used to say nothing at all
// about why. Syntax 6-8: `generate_region ::= generate { module_or_generate_item }
// endgenerate`. A bare `begin [: name] ... end` is a `generate_block`, and a
// `generate_block` appears in the grammar only as the body of a loop generate
// construct or of a conditional generate construct — never directly inside a
// generate region. §6.6 says the same in prose: the region is "a textual span in
// the module description where GENERATE CONSTRUCTS may appear", and a naked named
// block is not one. So this source has no production and a conforming compiler
// diagnoses it; there is no `//! xfail`.
//
// What is legal, and is deliberately NOT what this file writes, is the region
// holding a module_or_generate_item directly — `generate analog I(p) <+ V(p);
// endgenerate` — which VerA already accepts.
//
// The verdict now comes from the rule itself. It did not always: while a generate
// body was read as an analog STATEMENT this file died on the `analog` keyword
// (E0209, "expected an expression"), a parse boundary that had nothing to do with
// Syntax 6-8, and the earlier directive before that demanded the single word
// `expression`, which any parser error in the file could satisfy. Generate blocks
// hold module items now — the gap the five generate_if*/generate_two_loops
// fixtures named — so the `analog` keyword is fine here and the only thing left
// wrong with the source is the one thing the clause forbids: the naked `begin`.
// E0221 is that rule and nothing else, so this file fails for its own reason.
//
//! lrm 6.6
//! reject E0221
`include "disciplines.vams"
module ch6_generate_region(p);
  inout p; electrical p;
  generate
    begin : generated
      analog I(p) <+ V(p);
    end
  endgenerate
endmodule
