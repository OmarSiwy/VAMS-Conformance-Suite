// §6.3.5 Detecting parameter overrides:
//
//   "The $param_given() function (described in 9.19) can be used to determine
//    whether a PARAMETER value was obtained from the default value in its
//    declaration statement or if that value was overridden."
//
// and §9.19, which that sentence defers to, makes the operand a rule rather
// than a convention:
//
//   "The $param_given() function takes a single argument, WHICH MUST BE A
//    PARAMETER IDENTIFIER."   (Syntax 9-14: `$param_given ( module_parameter_identifier )`)
//
// The question §6.3.5 asks — default or override? — has no meaning for a
// variable: a variable has no declaration default that an instantiation could
// override (§6.3 lists defparam, the instance parameter value assignment and
// the paramset as the only three ways to alter a value, all three about
// parameters). `x` below is a `real` variable assigned in the analog block, and
// asking whether it was "given" is the error.
//
// `param_given.va` is the legal form, on a parameter, and it asserts the answer
// for an override; `param_given_absent.va` asserts it for a default.
//
// EXACTLY ONE RULE IS BROKEN: `$param_given(gain)` in the same place compiles.
//
//! lrm 6.3.5
//! lrm 9.19
//! lrm 9.19:3
//! reject-only E0822
//! reject requires a parameter identifier
//! neighbour param_given.va
//! neighbour param_given_absent.va
`include "disciplines.vams"
module ch6_param_given_variable(p);
  inout p; electrical p;
  parameter real gain = 1.0;
  real x;
  analog begin
    x = gain;
    I(p) <+ ($param_given(x) ? x : 1.0) * V(p);
  end
endmodule
