// §6.3.6's `badres`, the only source line in Clause 6 the LRM prints with a
// literal `// ERROR`, transcribed verbatim. The clause's own words: "The first
// example, badres, misuses the $mfactor such that the contributed current would be
// multiplied by $mfactor twice, once by the explicit multiplication and once by the
// automatic scaling rule. The simulator will generate an error for this module."
//
// The automatic rule is the first bullet of §6.3.6 — "All contributions to a branch
// flow quantity in the analog block shall be multiplied by $mfactor" — and the
// clause adds that "Verilog-AMS does not provide a method to disable" it. So the
// explicit `* $mfactor` below cannot be a deliberate opt-out; it can only be the
// double-scaling the paragraph before names: "The simulator shall issue a warning
// if it detects a misuse of the $mfactor in a manner that would result in
// double-scaling."
//
// That general sentence says WARNING while the sentence about this specific module
// says ERROR. This fixture pins the specific one, because it is the statement the
// LRM makes about this exact source; a compiler that only warns compiles the module
// and fails here, and that disagreement is worth surfacing rather than hiding
// behind a directive weak enough to pass either way.
//
// `parares` in the same clause is the legal companion — $mfactor read in a guard
// and not multiplied into the output — and is mfactor_conditional_only.va. It is
// the negative control: a check added for this file must not reject that one.
//
// The reject line is E0912, the code for this rule, as this header asked for
// while the generic `DiagnosticsReported` stood in for it. The predicate behind
// the code is the clause's sentence read literally — the CONTRIBUTED VALUE is a
// product in which $mfactor is a factor, for a FLOW. That is what separates this
// file from `parares`, where the read is in a guard; from a potential
// contribution, which §6.3.6 does not scale automatically; and from
// mfactor.va's `I(p) <+ V(p) + 0.0*$mfactor`, where the contributed value is
// V(p) and the factor multiplies an addend, not the current.
//
//! lrm 6.3.6
//! lrm 6.3.6:7
//! reject-only E0912
//! neighbour mfactor.va
//! neighbour mfactor_conditional_only.va
`include "disciplines.vams"
module badres(a, b);
  inout a, b;
  electrical a, b;
  parameter real r = 1.0 from (0:inf);
  analog begin
    I(a,b) <+ V(a,b) / r * $mfactor; // ERROR
  end
endmodule
