// AMS A.4.1 also forbids an ordered value after a named value. Reversing the
// mixed list must not bypass the prohibition. parameter_list_forms.va runs
// separate legal ordered and named lists.
//! lrm A.4.1
//! lrm A.4.1:1000
//! reject-only E0246
//! neighbour parameter_list_forms.va
`include "disciplines.vams"
module parameter_list_reverse_leaf(p);
  inout p; electrical p;
  parameter real a=3,b=7;
  analog I(p) <+ (a+b)*V(p);
endmodule
module parameter_list_mixed_reverse(p);
  inout p; electrical p;
  parameter_list_reverse_leaf #(.a(2),4) child(p);
endmodule
