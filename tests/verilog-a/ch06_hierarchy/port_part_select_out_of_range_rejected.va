// §6.5.5's "sub-range" of a vector port declared within the instantiating
// module (§6.5.1) lies inside the port's declared range. `o` is [3:0], so
// `o[5:2]` reaches two elements the port does not have: VerA refuses it with
// E0352, naming the declaration, instead of joining the cell to undeclared
// nets.
// The neighbour connects o[3:2] of the same kind of port.
//
//! lrm 6.5.5
//! lrm 6.5.1
//! reject-only E0352
//! reject so [5:2] is not a part of it
//! neighbour port_select_ordered_of_a_parent_port.va
`include "disciplines.vams"
module ch6_ppoor_top(p);
  inout p; electrical p;
  electrical [3:0] bus;
  ch6_ppoor_mid m(.o(bus), .c(p));
endmodule

module ch6_ppoor_mid(o, c);
  inout [3:0] o; inout c;
  electrical [3:0] o; electrical c;
  ch6_ppoor_quad u(.w(o[5:2]), .c(c));    // illegal: o is [3:0]
endmodule

module ch6_ppoor_quad(w, c);
  inout [3:0] w; inout c;
  electrical [3:0] w; electrical c;
  analog V(w[0], c) <+ 0.5;
endmodule
