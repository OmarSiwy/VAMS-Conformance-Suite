// §6.4.1: "Restrictions on statements in a paramset are similar to those for
// analog functions. Specifically, a paramset: ... Shall not use contribution
// statements or event control statements."
//
// The event control is isolated: `@(initial_step) v = 1.0;` uses no access
// function (the separate "Shall not use access functions" rule), no named
// block, and no contribution, inside an unnamed `begin ... end` that the
// neighbour keeps. The neighbour paramset_statement_without_event_control.va
// is this file without the `@(initial_step)`, and compiles.
//
// A contribution cannot be isolated the same way: its left-hand side is always
// an access function (§5.6.1), so a contribution in a paramset also breaks the
// access-function rule, which reject_6_4_1_paramset_access_function.va pins.
//
//! lrm 6.4.1
//! lrm 6.4.1:2
//! lrm 6.4.1:1
//! reject-only an event control
//! neighbour paramset_statement_without_event_control.va
`include "disciplines.vams"
module b4_pec_top(p, n);
  inout p, n; electrical p, n;
  b4_pec_ps u(p, n);
endmodule

paramset b4_pec_ps b4_pec_base;
  real v;
  .k = 2.0;
  begin
    @(initial_step) v = 1.0;
  end
endparamset

module b4_pec_base(a, b);
  inout a, b; electrical a, b;
  parameter real k = 9.0;
  analog I(a, b) <+ k * V(a, b);
endmodule
