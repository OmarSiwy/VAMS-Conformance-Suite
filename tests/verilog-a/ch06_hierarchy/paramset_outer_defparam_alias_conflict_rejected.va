// §3.4.7 forbids overriding by both an original name and an alias, regardless
// of whether the mechanisms are inline assignment or defparam, and even when
// the values are equal. The alias fixture uses the SAME alias twice legally;
// the later defparam then wins under §6.3.
//! lrm 3.4.7
//! lrm 3.4.7:4
//! reject-only E0908
`include "disciplines.vams"
module ps_outer_conflict_top(p);
  inout p; electrical p;
  ps_outer_conflict_card #(.w(2.0)) u(p);
  defparam u.width=2.0;
endmodule
paramset ps_outer_conflict_card ps_outer_conflict_leaf;
  parameter real w=1.0;
  aliasparam width=w;
  .gain=w;
endparamset
module ps_outer_conflict_leaf(p);
  inout p; electrical p;
  parameter real gain=1.0;
  analog I(p) <+ gain*V(p);
endmodule
