// §6.2: "A module definition shall be enclosed between the keywords module and
// endmodule." The module below opens with `module` and reaches end of file with
// no `endmodule`, so it is not a module definition. A.1.2 gives the definition
// its closing keyword; the parser reports E0207 where it expected `endmodule`.
//
// module_definition.va is the legal neighbour: the same module with its closing
// keyword.
//
//! lrm 6.2
//! lrm 6.2:1
//! reject-only E0207
//! neighbour module_definition.va
`include "disciplines.vams"
module ch6_missing_endmodule(p);
  inout p; electrical p;
  analog I(p) <+ V(p);
