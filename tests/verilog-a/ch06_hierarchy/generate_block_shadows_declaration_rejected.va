// §6.6.2, verbatim: "Named generate blocks may not have the same name as ANY
// OTHER DECLARATION IN THE SAME SCOPE."
//
// `begin : sel` inside the if-generate construct is not a label — §6.6.2 says
// "its name declares a generate block instance and is the name for the scope it
// creates", so `sel` lands in the module's ordinary declaration space, where
// `real sel;` already is. Two items, one identifier, one scope. §6.8 says the
// same in general terms ("An identifier shall be used to declare only one item
// within a scope ... For generate blocks, this rule applies regardless of whether
// the generate block is instantiated").
//
// The pairing with a plain variable is deliberate and is what separates this from
// its sibling generate_block_name_collision_rejected.va: that one collides two
// generate block names with each other, which a compiler keeping generate names
// in a table of their own would still catch. This one fails that compiler,
// because the rule is that the block name is an ORDINARY declaration of the
// module scope. generate_array_name_conflict_rejected.va is the §6.6.1 form of
// the same collision, for a loop construct's instance ARRAY rather than a
// conditional construct's single block.
//
// The condition is `1`, so the block IS selected — the collision here does not
// depend on the "even if not selected" extension, which the sibling covers.
//
// E0230 is that rule. It compares the block name against every ordinary
// declaration slice of the module — ports, parameters, variables, nets, branches,
// genvars, analog functions, aliasparams — which is the ONE declaration space the
// clause puts it in.
//
//! lrm 6.6.2
//! lrm 6.6.2:3
//! lrm 6.8
//! lrm 6.8:1
//! reject-only E0230
//! neighbour generate_if_true.va
`include "disciplines.vams"
module ch6_generate_block_shadows_declaration(p);
  inout p; electrical p;
  real sel;
  generate
    if (1) begin : sel
      localparam integer k = 1;
    end
  endgenerate
  analog begin
    sel = 1.0;
    I(p) <+ sel * V(p);
  end
endmodule
