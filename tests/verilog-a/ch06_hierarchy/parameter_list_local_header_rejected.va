// AMS A.1.3 names parameter_declaration, whose A.2.1.1 arm starts with
// parameter. A local_parameter_declaration is a separate arm, legal in the
// body as parameter_list_forms.va shows, but absent from this header grammar.
//! lrm A.1.3
//! lrm A.1.3:1000
//! reject-only E0246
//! neighbour parameter_list_forms.va
`include "disciplines.vams"
module parameter_list_local_header #(parameter a=3, localparam b=7) (p);
  inout p; electrical p;
  analog I(p) <+ (a+b)*V(p);
endmodule
