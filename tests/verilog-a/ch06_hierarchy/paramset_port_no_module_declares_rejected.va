// §6.4.2: "When choosing an appropriate paramset, the following rules shall be
// enforced: ... The underlying module shall have a port declared for each port
// connected in the instance line."
//
// u3 connects `.d(q)`. Neither candidate module declares a port d (b4_pps_two
// has a, b; b4_pps_three has a, b, c), so no paramset named b4_pps is
// applicable and u3 cannot be elaborated. The neighbour
// paramset_connected_ports_select_the_module.va is this file with `.c(q)`,
// a port b4_pps_three declares.
//
//! lrm 6.4.2
//! lrm 6.4.2:6
//! reject-only E0911
//! neighbour paramset_connected_ports_select_the_module.va
`include "disciplines.vams"
module b4_pps_top(p, n, q);
  inout p, n, q; electrical p, n, q;
  b4_pps #(.g(3.0)) u3(.a(p), .b(n), .d(q));
  b4_pps #(.g(2.0)) u2(.a(p), .b(n));
endmodule

paramset b4_pps b4_pps_two;
  parameter real g = 1.0;
  .k = g;
endparamset

paramset b4_pps b4_pps_three;
  parameter real g = 1.0;
  .k = g;
endparamset

module b4_pps_two(a, b);
  inout a, b; electrical a, b;
  parameter real k = 0.0;
  analog I(a, b) <+ k * V(a, b);
endmodule

module b4_pps_three(a, b, c);
  inout a, b, c; electrical a, b, c;
  parameter real k = 0.0;
  analog I(a, b) <+ k * V(a, b);
endmodule
