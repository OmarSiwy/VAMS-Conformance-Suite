// Syntax 6-8: `generate_block ::= module_or_generate_item | begin
// [ : generate_block_identifier ] { module_or_generate_item } end`. The `end`
// is not optional. §2.9 makes an attribute instance "a prefix attached to" what
// follows it, and here nothing follows it: the file ends inside the block, right
// after `(* a *)`.
//
// So the block below has no `end` and the module no `endmodule`. Both are
// E0207 ("unexpected token", found end of file), the code every other missing
// terminator gets, and nothing else is wrong with the source. Before #48 the
// parser tried to read a module item at end of file, failed without moving, and
// its recovery stepped past the end of the token stream (a crash, not a
// diagnostic). Since #49 the instance itself, which prefixes nothing, is a
// third E0207.
//
// Legal neighbour: generate_block_attribute_then_end.va, the same block with its
// attribute prefixing an analog construct and the block closed.
//
//! lrm 6.6
//! reject-only E0207
//! neighbour generate_block_attribute_then_end.va
`include "disciplines.vams"
module ch6_gen_attr_eof(p);
  inout p; electrical p;
  if (1) begin (* a *)
