// §6.4.3 Paramset output variables:
//
//   "Integer or real variables in the paramset declared with descriptions are
//    considered output variables (see 3.2.1). Special rules:
//      ...
//      IF A PARAMSET VARIABLE WITHOUT A DESCRIPTION HAS THE SAME NAME AS A
//      MODULE OUTPUT VARIABLE, THE MODULE OUTPUT VARIABLE SHALL NOT BE
//      AVAILABLE FOR INSTANCES USING THE PARAMSET."
//
// and §9.16 is the language's own way of asking an instance for an output
// variable, with the consequence of asking for one that is not available:
//
//   "$simprobe() queries the simulator for an output variable named param_name
//    in a sibling instance called inst_name. ... If either the inst_name or
//    param_name cannot be resolved, and the optional expression is not
//    supplied, then an error shall be generated."
//
// The module `ch6_pshide_dev` declares `id` WITH a description — an output
// variable, which `simprobe_reads_a_sibling_output_variable.va` shows
// $simprobe reads from a plain module instance. Here the instance `u_dev` uses
// the paramset `ch6_pshide_ps`, which declares its own `real id;` WITHOUT a
// description. For this instance the module's `id` "shall not be available", so
// the monitor's `$simprobe("u_dev", "id")` names nothing it can resolve, and it
// supplies no fallback: an error.
//
// WHAT USED TO HAPPEN: the probe read the module's `id` straight through the
// paramset — VerA did not record which paramset variables carry a description,
// so it could not apply the rule.
//
// EXACTLY ONE RULE IS BROKEN: give the paramset's `id` a `(* desc = "..." *)`
// (it then REPLACES the module's for reporting, the clause's first rule), or
// give the probe a fallback `$simprobe("u_dev", "id", -1.0)`, and the design is
// legal. `ch6_pshide_dev`'s parameter `scale` stays probe-able: the rule hides
// output VARIABLES, not parameters.
//
//! lrm 6.4.3
//! lrm 6.4.3:1
//! lrm 9.16
//! lrm 9.16:1
//! reject-only E0817
//! neighbour paramset_hidden_output_variable_takes_the_fallback.va
//! reject `$simprobe("u_dev", "id")`
`include "disciplines.vams"
module ch6_pshide_top(p, n);
  inout p, n;
  electrical p, n;
  ch6_pshide_ps u_dev(p, n);
  ch6_pshide_mon u_mon(p, n);
endmodule

paramset ch6_pshide_ps ch6_pshide_dev;
  real id;
  .scale = 4.0;
endparamset

module ch6_pshide_dev(a, b);
  inout a, b;
  electrical a, b;
  parameter real scale = 1.0;
  (* desc = "branch current" *) real id;
  analog begin
    id = scale * V(a, b);
    I(a, b) <+ id;
  end
endmodule

module ch6_pshide_mon(a, b);
  inout a, b;
  electrical a, b;
  real probe;
  analog begin
    probe = $simprobe("u_dev", "id");
    I(a, b) <+ 0.0 * probe * V(a, b);
  end
endmodule
