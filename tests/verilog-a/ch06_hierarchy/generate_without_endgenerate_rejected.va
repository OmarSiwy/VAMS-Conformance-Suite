// §6.6: "If the generate keyword is used, it shall be matched by an
// endgenerate keyword." The region below opens with `generate` and never
// closes; the parser reaches `endmodule` while still inside the region and
// reports E0207, "expected endgenerate".
//
// generate_if_true.va is the legal neighbour, a complete generate region with
// its matching endgenerate.
//
//! lrm 6.6
//! lrm 6.6:8
//! reject-only E0207
//! neighbour generate_if_true.va
`include "disciplines.vams"
module ch6_noendgen(p);
  inout p; electrical p;
  generate
    if (1) begin : g
      localparam integer k = 1;
    end
  analog I(p) <+ V(p);
endmodule
