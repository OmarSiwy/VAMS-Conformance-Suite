// §6.6.1, verbatim: "Both the initialization and iteration assignments in the loop
// generate scheme shall assign to the same genvar. THE INITIALIZATION ASSIGNMENT
// SHALL NOT REFERENCE THE LOOP INDEX VARIABLE ON THE RIGHT-HAND SIDE."
//
// `i = i + 1` in the init position does exactly that. The rule is not a
// restatement of the constant-expression requirement: `i` IS a genvar, so it is a
// legal `genvar_primary` in Syntax 6-8's `genvar_expression`, and it is precisely
// the initialization slot the LRM carves out, because at that point the loop has
// not run and the index has no value to read. A conforming compiler diagnoses it
// and there is no `//! xfail`.
//
// VerA reaches the verdict one step to the side: it tries to constant-fold the
// initial value, finds `i` unbound because nothing has assigned it yet, and
// reports E0417, "genvar loop bound is not a constant expression: initial value of
// `i`". The right verdict from the adjacent rule; its sibling
// generate_nonconstant_init_rejected.va pins the same code from the
// constant-expression side, with a runtime `integer` on the right-hand side
// instead of the index.
//
// The block body is an EMPTY `begin end`: Syntax 6-8's `generate_block ::=
// module_or_generate_item | begin [ : id ] { module_or_generate_item } end` admits no
// bare statement — a contribution is reachable only through `analog_construct ::=
// analog analog_statement` — so the `I(p) <+ V(p);` this file used to write there was
// a VerA parser extension, and a conforming compiler would have rejected the body
// and never evaluated the loop scheme the directive below pins.
//! lrm 6.6.1
//! lrm 6.6.1:4
//! reject-only E0417
//! neighbour generate_loop.va
`include "disciplines.vams"
module ch6_genvar_init_self_reference(p);
  inout p; electrical p;
  genvar i;
  generate
    for (i = i + 1; i < 3; i = i + 1) begin end
  endgenerate
endmodule
