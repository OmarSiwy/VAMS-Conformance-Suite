// §6.5.5: a port expression is a "scalar member" or "sub-range" of a net the
// instantiating module declares, and §3.6.3 scalarises `electrical [1:0] r`
// into exactly r[1] and r[0]. So `.v(r[2])` names a member that was never
// declared: VerA refuses it with E0352, naming the declared range, instead of
// joining the port to an undeclared net.
// The neighbour connects r[i] for every declared i.
//
//! lrm 6.5.5
//! lrm 3.6.3
//! reject-only E0352
//! reject so 2 is not one of its elements
//! neighbour port_select_genvar_index.va
`include "disciplines.vams"
module ch6_psel_oor_top(p);
  inout p; electrical p;
  electrical [1:0] r;
  ch6_psel_oor_one u(.v(r[2]), .c(p));    // illegal: r is [1:0]
  ch6_psel_oor_one w(.v(r[1]), .c(p));
endmodule

module ch6_psel_oor_one(v, c);
  inout v, c; electrical v, c;
  analog V(v, c) <+ 0.5;
endmodule
