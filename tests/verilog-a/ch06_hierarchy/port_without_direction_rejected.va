// §6.5.2.2, verbatim: "Each port shall be declared as input, output, or inout
// (bidirectional), in addition to any other declaration (e.g., discipline,
// reg, or wire)." §6.2 says the same of the list of ports: "The identifiers
// in this list shall be declared in input, output, and inout declaration
// statements within the module definition."
//
// `c` is listed in the header and declared `electrical`, which gives it a
// discipline (§6.5.2.1) and nothing else: no statement gives it a direction.
// Everything else in the module is legal, so the only defect is the one under
// test. VerA refuses it with E0376, "port has no direction declaration" (#73;
// the digital engine refuses the same omission in a `.v` design with E1100,
// ieee1364/12_hierarchy/listed_port_undeclared_rejected.v).
//
// The legal neighbour, port_directions.va, declares every listed port's
// direction and runs.
//
//! lrm 6.5.2.2
//! lrm 6.5.2.2:1
//! lrm 6.2
//! lrm 6.2:5
//! reject-only E0376
//! neighbour port_directions.va
`include "disciplines.vams"
module ch6_port_without_direction(c);
  electrical c;
  analog I(c) <+ V(c);
endmodule
