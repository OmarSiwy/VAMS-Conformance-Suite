// A part-select reads in its vector's declared direction: IEEE 1364-2005
// §5.2.1 (inherited through §1.1) on `vect[msb_expr:lsb_expr]`, "The first
// expression has to address a more significant bit than the second
// expression." On `electrical [7:0] d`, bit 7 is the most significant, so
// d[7:4] is a §6.5.5 sub-range and d[4:7] is not. VerA refuses the reversed
// select with E0352, as it does on a branch terminal
// (ch03_data_types/vector_branch_part_select_reversed_rejected.va).
// The neighbour connects d[4 +: 4], which is d[7:4].
//
//! lrm 6.5.5
//! reject-only E0352
//! reject so [4:7] is not a part of it
//! neighbour port_select_indexed_part_select.va
`include "disciplines.vams"
module ch6_psrev_top(p);
  inout p; electrical p;
  electrical [7:0] d;
  ch6_psrev_quad u(.w(d[4:7]), .c(p));    // illegal: reverses the declared [7:0]
endmodule

module ch6_psrev_quad(w, c);
  inout [3:0] w; inout c;
  electrical [3:0] w; electrical c;
  analog V(w[0], c) <+ 0.5;
endmodule
