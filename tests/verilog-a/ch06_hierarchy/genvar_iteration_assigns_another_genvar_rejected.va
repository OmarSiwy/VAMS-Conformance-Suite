// §6.6.1 Loop generate constructs, "Rules: Both the initialization and
// iteration assignments shall assign to the same genvar."
//
// The initialization assigns i; the iteration assigns j. Everything else is
// legal: both are declared genvars, the condition `i < 0` is false at the
// start, so the loop terminates with zero trips (no "does not terminate"
// error, §6.6.1), no genvar value repeats, and j, never evaluated, is never
// set to x. The rule is a property of the text, not of a trip, so a zero-trip
// loop still breaks it. The neighbour genvar_loop_with_zero_trips.va is
// this file with `i = i + 1`.
//
// generate_mismatched_genvar_rejected.va writes `i < 2` with `j = j + 1`; its
// E0419 names the non-constant step, and i never changes, so that loop also
// fails to terminate. This file isolates the same-genvar rule.
//
//! lrm 6.6.1
//! lrm 6.6.1:3
//! reject-only genvar
//! neighbour genvar_loop_with_zero_trips.va
`include "disciplines.vams"
module b4_gzt(p);
  inout p; electrical p;
  genvar i, j;
  integer n;
  analog n = 0;
  generate
    for (i = 0; i < 0; j = j + 1) begin : g
      analog n = n + 1;
    end
  endgenerate
  analog I(p) <+ V(p);
endmodule
