// §6.6.3 names unnamed generate blocks, and the FIRST sentence of the clause says
// what that name is for — and what it is not for: "Although an unnamed generate
// block HAS NO NAME THAT CAN BE USED IN A HIERARCHICAL NAME, it needs to have a
// name by which EXTERNAL INTERFACES can refer to it." §6.6.2 states the same rule
// from the other side: "If the generate block selected for instantiation is not
// named, it still creates a scope; but the declarations within it cannot be
// referenced using hierarchical names other than from within the hierarchy
// instantiated by the generate block itself." And §6.6's introduction only ever
// promises "Names in instantiated NAMED generate blocks can be referenced
// hierarchically as described in 6.7."
//
// THIS FIXTURE USED TO SAY THE OPPOSITE. It was a run fixture asserting that
// `genblk1.tag` and `genblk02.tag` resolve from an `analog` block at module scope,
// reading the `// top.genblk1.a` trailing comments in §6.6.3's `module top` as
// proof. Those comments annotate the EXTERNAL (VPI / user-interface) name the
// paragraph above them has just defined; they are not HDL that the LRM compiles.
// The `analog begin` below is at module scope, outside both generate blocks, so it
// is exactly the "other than from within the hierarchy instantiated by the generate
// block itself" case §6.6.2 forbids. A conforming compiler refuses this source.
//
// The numbering itself is right and is kept here as prose, because §6.6.3 is an
// external-interface rule with no in-HDL oracle: `genblk2` is a declared parameter,
// so the first unnamed if-generate construct is `genblk1`, the second would collide
// and becomes `genblk02`. Nothing in this suite can read those names back; what can
// be pinned is that the HDL path built from them is illegal.
//
// VerA refuses both paths with E0998, "reaches into `genblk1`, an unnamed
// generate block" (until 2026-10-08 it said E0901, "names nothing in the
// elaborated design": right refusal, wrong reason, since §6.6.2 is the rule).
// unnamed_generate_instance_reference_rejected.va refuses the same reach to an
// instance, whose flat name does exist, beside a named-block neighbour.
//
//! lrm 6.6.2
//! lrm 6.6.3
//! reject-only E0998
`include "disciplines.vams"
module ch6_external_genblk_reference(p);
  inout p; electrical p;
  parameter integer genblk2 = 0;
  generate
    if (1) begin
      localparam real tag = 1.0;
    end
    if (1) begin
      localparam real tag = 2.0;
    end
  endgenerate
  analog I(p) <+ (genblk1.tag + genblk02.tag) * V(p);
endmodule
