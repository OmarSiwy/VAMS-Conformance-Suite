// §6.6: "all expressions in generate schemes shall be constant expressions,
// deterministic at elaboration time", and §6.6.1 spells the loop's three parts
// out: `genvar_initialization ::= genvar_identifier = constant_expression`
// (Syntax 6-8). The genvar "is used as an integer DURING ELABORATION to evaluate
// the generate loop and create instances of the generate block, but it does not
// exist at simulation time" — so an initial value that is only known at simulation
// time leaves the elaborator with no number and no way to unroll.
//
// `rv` is an ordinary `integer` variable assigned inside an analog block, i.e. a
// runtime value, so the LRM gives this loop no semantics and the expected
// behavior IS the diagnostic. VerA reports it at the rule: E0417, "genvar loop
// bound is not a constant expression: initial value of `i`".
//
// Its two siblings hold the other two parts of the same sentence:
// generate_nonconstant_condition_rejected.va (E0418) and
// generate_mismatched_genvar_rejected.va (E0419, the step).
//
// The block body is an EMPTY `begin end`: Syntax 6-8's `generate_block ::=
// module_or_generate_item | begin [ : id ] { module_or_generate_item } end` admits no
// bare statement — a contribution is reachable only through `analog_construct ::=
// analog analog_statement` — so the `I(p) <+ V(p);` this file used to write there was
// a VerA parser extension, and a conforming compiler would have rejected the body
// and never evaluated the loop scheme the directive below pins.
//! lrm 6.6.1
//! lrm 6.6
//! lrm 6.6:2
//! reject-only E0417
`include "disciplines.vams"
module ch6_generate_nonconstant_init(p);
  inout p; electrical p;
  integer rv;
  genvar i;
  analog rv = 1;
  generate
    for (i = rv; i < 3; i = i + 1) begin end
  endgenerate
endmodule
