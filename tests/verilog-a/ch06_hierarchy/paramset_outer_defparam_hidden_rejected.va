// §6.4's nmos3 example says an instance cannot override an underlying module
// parameter the paramset does not expose. An outer defparam has the same
// boundary: secret belongs only to the underlying module, so no member admits
// this binding. The precedence fixture exposes and overrides w legally.
//! lrm 6.4
//! lrm 6.4.2
//! lrm 6.4.2:3
//! reject E0911
`include "disciplines.vams"
module ps_outer_hidden_top(p);
  inout p; electrical p;
  ps_outer_hidden_card u(p);
  defparam u.secret=7.0;
endmodule
paramset ps_outer_hidden_card ps_outer_hidden_leaf;
  parameter real w=1.0;
  .gain=w;
endparamset
module ps_outer_hidden_leaf(p);
  inout p; electrical p;
  parameter real gain=1.0, secret=2.0;
  analog I(p) <+ gain*V(p);
endmodule
