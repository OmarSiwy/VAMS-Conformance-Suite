// §6.4: "A chain of paramsets may be defined in this way, but the last
// paramset in the chain shall reference a module."
//
// Chain: b4_pce_near -> b4_pce_far -> b4_pce_nowhere. The far link is the
// last paramset of the chain (no paramset is named b4_pce_nowhere), and its
// second identifier names no module either, so the instance `u` has no module
// to elaborate. The neighbour paramset_chain_ends_at_a_module.va differs in
// that one identifier: there the far link names the module b4_pce_base.
//
// b4_pce_base is kept so the two files differ only in the broken link. Here
// nothing instantiates it, so it is a second top-level module (§6.2.1), which
// is legal and is not what is refused.
//
//! lrm 6.4
//! lrm 6.4:2
//! reject-only E0904
//! neighbour paramset_chain_ends_at_a_module.va
`include "disciplines.vams"
module b4_pce_top(p, n);
  inout p, n; electrical p, n;
  b4_pce_near u(p, n);
endmodule

paramset b4_pce_near b4_pce_far;
  real tag;
  tag = 1.0;
endparamset

paramset b4_pce_far b4_pce_nowhere;
  real tag;
  .j = 2.0;
endparamset

module b4_pce_base(a, b);
  inout a, b; electrical a, b;
  parameter real j = 0.0;
  analog I(a, b) <+ j * V(a, b);
endmodule
