// §6.5.5: "The port name cannot be a bit select or a part select." A named
// connection names a port of the child module, not a net of the parent: `.a`
// is the child's port, and `.a[0]` asks for a bit of that port name. The
// grammar's named connection is `. port_identifier ( [ port_expression ] )`,
// so a select after the identifier has no production; the parser reports
// E0207 at `[`.
//
// named_port_expressions.va is the legal neighbour: named connections whose
// port names are bare identifiers, with the selects written on the PARENT's
// net expressions inside the parentheses.
//
//! lrm 6.5.5
//! lrm 6.5.5:1001
//! reject-only E0207
//! neighbour named_port_expressions.va
`include "disciplines.vams"
module ch6_npbs_top(p);
  inout p; electrical p;
  ch6_npbs_kid u(.a[0](p));
endmodule

module ch6_npbs_kid(a);
  inout a; electrical a;
  analog I(a) <+ 0.0;
endmodule
