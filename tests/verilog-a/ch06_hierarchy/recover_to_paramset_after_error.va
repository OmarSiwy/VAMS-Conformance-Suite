// A.1.2 source_text is a SEQUENCE of descriptions, so error recovery at the
// top level has one job: resynchronize on the next token that can START a
// description, and parse it. `paramset` (A.1.9) is such a token, and VerA's
// resync set used to omit it — after any top-level error the scan ran straight
// THROUGH a following paramset declaration looking for `module`, swallowing it
// whole. One stray token then cost every paramset after it, silently: no
// second diagnostic, just an overload set missing members.
//
// The pin is two diagnostics from one file. The stray `frobnicate` is E0201
// (not a description); recovery must then LAND on the paramset and parse its
// body, where the misspelled `paramter` is E0205 (the A.1.9 body check,
// paramset_misspelled_item_rejected.va). A parser that swallows the paramset
// during recovery reports the first error only and fails this file on the
// missing second substring — which is exactly the old behaviour.
//
//! lrm A.1.2
//! lrm A.1.9
//! lrm A.1.2:1000
//! reject-only E0201
//! reject E0205
`include "disciplines.vams"
frobnicate

paramset ch6_rec_ps ch6_rec_base;
  paramter real rr = 5.0;
  .k = 2.0;
endparamset

module ch6_rec_base(a, b);
  inout a, b; electrical a, b;
  parameter real k = 9.0;
  analog I(a, b) <+ k * V(a, b);
endmodule
