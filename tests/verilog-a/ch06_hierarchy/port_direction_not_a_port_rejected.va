// §6.5.2: "The type and direction of EACH PORT LISTED IN THE MODULE DEFINITION'S
// LIST OF PORTS are declared in the body of the module", and §6.2 fixes the
// correspondence in the other direction: "The identifiers in this list shall be
// declared in input, output, or inout declaration statements within the module
// definition." A direction declaration is therefore a declaration ABOUT a port,
// not a way to create one — the set it may name is exactly the header's list.
//
// `q` is not in that list. Nothing in Clause 6 gives `inout q;` a meaning here:
// it is neither a port declaration (no such port) nor a net declaration (a net is
// declared by its discipline, §6.5.2.1 / A.2.1.3), so the source is ill-formed and
// a conforming compiler diagnoses it. VerA does, at the rule and not at a parse
// boundary: E0206, "identifier is not a port of this module".
//
// The mirror-image mistake — a port declared in the header's list of port
// DECLARATIONS and then redeclared in the body — is ansi_port_redeclared_rejected.va.
//
//! lrm 6.5.2
//! lrm 6.2
//! reject-only E0206
`include "disciplines.vams"
module ch6_port_direction_not_a_port(p);
  inout p; electrical p;
  inout q;
  analog I(p) <+ V(p);
endmodule
