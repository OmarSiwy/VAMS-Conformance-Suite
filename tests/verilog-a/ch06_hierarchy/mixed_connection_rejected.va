// §6.5.5: "The two types of module port connections can not be mixed;
// connections to the ports of a particular module instance shall be all by
// order or all by name."
//
// This is the mix in the ORDER the sibling check could not see. A list whose
// first entry is named already rejects a later positional entry (E0906, "an
// ordered connection in a list of named connections"); but a list whose first
// entry is positional used to be treated as ordered THROUGHOUT, so the `.a(n)`
// below bound net `n` to port `b` — second position, name ignored — and the
// instance linted clean while connecting the exact opposite of what either
// reading of the source says. A silently ignored port NAME is a miswired
// netlist, so the mix is a diagnostic in both directions.
//
//! lrm 6.5.5
//! lrm 6.5.5:4
//! reject-only E0906
//! reject a named connection in a list of ordered connections
//! neighbour named_port_expressions.va
`include "disciplines.vams"
module ch6_mixed_conn_parent(p, n);
  inout p, n; electrical p, n;
  ch6_mixed_conn_kid u(p, .a(n));
endmodule

module ch6_mixed_conn_kid(a, b);
  inout a, b; electrical a, b;
  analog I(a, b) <+ V(a, b);
endmodule
