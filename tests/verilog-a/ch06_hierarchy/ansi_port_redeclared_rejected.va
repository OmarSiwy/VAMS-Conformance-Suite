// §6.2, verbatim: "PORTS DECLARED IN THE LIST OF PORT DECLARATIONS SHALL NOT BE
// REDECLARED WITHIN THE BODY OF THE MODULE."
//
// "List of port declarations" is the ANSI header form — Syntax 6-1 gives the
// module header either a `list_of_ports` (bare identifiers, declared in the body)
// or a `list_of_port_declarations` (direction and discipline in the header). This
// module uses the second, so `inout electrical p` in the header is the ONE
// declaration of `p` the LRM allows, and the body line repeats it.
//
// The two header forms are exclusive and that is what makes this a rule of its own
// rather than an instance of §6.8's duplicate-declaration prohibition: the same
// body line is REQUIRED after a bare `module m(p);` (nonansi_ports.va does exactly
// that) and forbidden after this header. A compiler that merged the two forms into
// one port table and tolerated a second write passes both and distinguishes
// neither. output_port.va's header already asserts this rule in prose and has no
// way to test it, being a legal module.
//
// The mirror-image mistake — a direction declaration naming an identifier that is
// not a port at all — is port_direction_not_a_port_rejected.va, and VerA does
// diagnose that one (E0206, whose explain text already quotes the sentence above).
//
// E0218 is that diagnostic, raised by parser.zig parsePortDecl. The test is the
// port's DIRECTION: Syntax 6-1 lets only a `list_of_port_declarations` header
// carry one, so a port that already has a direction when a body declaration
// names it was declared once already.
//
// The `//! lrm 6.5.2` this file used to carry has been dropped. That clause says
// "The type and direction of each port listed in the module definition's list of
// ports are declared in the body of the module", which describes the NON-ANSI form
// and, read alone, licenses exactly the body declaration this fixture forbids. §6.2
// is the sentence quoted at the top and is the whole authority here.
//
//! lrm 6.2
//! lrm 6.2:6
//! reject-only E0218
//! neighbour nonansi_ports.va
//! neighbour output_port.va
`include "disciplines.vams"
module ch6_ansi_port_redeclared(inout electrical p);
  inout electrical p;
  analog I(p) <+ V(p);
endmodule
