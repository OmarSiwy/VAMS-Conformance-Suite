// §6.5.5: "The parentheses are required." A named connection is
// `. port_identifier ( [ port_expression ] )`; `.a` with no parentheses names
// the port but supplies no connection expression at all. (An EMPTY pair,
// `.a()`, is legal and means "not connected" — empty_named_connection_unsupported.va.)
// The parser reports E0207 where the `(` belongs.
//
// named_port_expressions.va is the legal neighbour, every named connection
// written with its parentheses.
//
//! lrm 6.5.5
//! lrm 6.5.5:1002
//! reject-only E0207
//! neighbour named_port_expressions.va
`include "disciplines.vams"
module ch6_npwp_top(p);
  inout p; electrical p;
  ch6_npwp_kid u(.a);
endmodule

module ch6_npwp_kid(a);
  inout a; electrical a;
  analog I(a) <+ 0.0;
endmodule
