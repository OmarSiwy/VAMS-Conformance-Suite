// §6.3 allows this outer binding, which selects the k=1 paramset. Its
// associated module contains a defparam, forbidden by §6.3.1/§6.4. Applying a
// legal OUTER defparam must not bypass the ban on statements INSIDE the
// selected paramset hierarchy. The precedence fixture selects legal bodies.
//! lrm 6.3.1
//! lrm 6.4
//! lrm 6.3.1:2
//! reject-only E0926
`include "disciplines.vams"
module ps_outer_forbidden_top(p);
  inout p; electrical p;
  ps_outer_forbidden_card #(.k(0)) u(p);
  defparam u.k=1;
endmodule
paramset ps_outer_forbidden_card ps_outer_forbidden_good;
  parameter integer k=0 from (-inf:1);
  .gain=1.0;
endparamset
paramset ps_outer_forbidden_card ps_outer_forbidden_bad;
  parameter integer k=0 from [1:inf);
  .gain=2.0;
endparamset
module ps_outer_forbidden_bad(p);
  inout p; electrical p;
  parameter real gain=1.0;
  ps_outer_forbidden_good child(p);
  defparam child.gain=gain;
endmodule
module ps_outer_forbidden_good(p);
  inout p; electrical p;
  parameter real gain=1.0;
  analog I(p) <+ gain*V(p);
endmodule
