// §6.6: "all expressions in generate schemes shall be constant expressions,
// deterministic at elaboration time." `runtime_value` is an integer VARIABLE, so
// the if-generate condition is not elaboration-time constant. The LRM gives the
// construct no semantics -- the expected behavior IS the diagnostic.
//
// The selected block is the NULL statement, and that is deliberate:
// `if_generate_construct ::= if ( constant_expression ) generate_block_or_null` and
// `generate_block_or_null ::= generate_block | ;` (Syntax 6-8), so `;` is the
// smallest legal body there is. This file used to write a bare `I(p) <+ V(p);`
// there instead, which has no production at all -- `generate_block ::=
// module_or_generate_item | begin ... end`, and a contribution is reachable only
// through `analog_construct ::= analog analog_statement`. That pinned a VerA parser
// extension, and it also meant a conforming compiler would reject the body and
// never look at the condition this fixture is about.
//
// E0428 is that rule, judged in lowering because that is the only stage that can
// evaluate a constant expression. A `parameter` in the same position is ACCEPTED
// and must be: A.8.4 makes it a `constant_primary` and §6.6's stated purpose is
// "the ability for parameter values to affect the structure of the model".
// generate_direct_nesting.va and generate_implicit_region_unsupported.va are that
// side; a module variable is this one.
//! lrm 6.6
//! lrm 6.6:2
//! reject-only E0428
//! neighbour generate_direct_nesting.va
//! neighbour generate_implicit_region_unsupported.va
`include "disciplines.vams"
module ch6_generate_nonconstant(p);
  inout p; electrical p; integer runtime_value;
  generate
    if (runtime_value) ;
  endgenerate
  analog I(p) <+ V(p);
endmodule
