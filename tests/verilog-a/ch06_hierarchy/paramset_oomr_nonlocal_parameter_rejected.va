// §6.4.1: "The right-hand side can be composed of numbers, parameters, and
// hierarchical out-of-module references to local parameters of a different
// module. Hierarchical out-of-module references to non-local parameters are
// disallowed."
//
// The paramset's `.k` reads `ch6_psnl_lib.tox`, where `tox` is declared with
// plain `parameter` — not `localparam`. The reference names a real declaration
// of a real module, so the path resolves; the defect is the parameter's KIND.
// VerA reports E0907: "`ch6_psnl_lib.tox` is a parameter, and §6.4.1 allows a
// paramset to reach out of module only to a LOCAL parameter".
//
// paramset_oomr_localparam.va is the legal neighbour: the same
// out-of-module read over a `localparam`.
//
//! lrm 6.4.1
//! lrm 6.4.1:1002
//! reject-only E0907
//! neighbour paramset_oomr_localparam.va
`include "disciplines.vams"
module ch6_psnl_top(p);
  inout p; electrical p;
  ch6_psnl_ps u(p);
endmodule

paramset ch6_psnl_ps ch6_psnl_base;
  parameter real w = 2.0;
  .k = ch6_psnl_lib.tox * w;
endparamset

module ch6_psnl_base(a);
  inout a; electrical a;
  parameter real k = 0.0;
  analog I(a) <+ k * V(a);
endmodule

module ch6_psnl_lib;
  parameter real tox = 3.0;
endmodule
