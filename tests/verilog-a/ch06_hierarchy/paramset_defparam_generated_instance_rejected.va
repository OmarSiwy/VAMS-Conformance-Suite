// §6.6.2 selects this else arm. Its paramset instance has an associated module
// containing defparam, so §6.3.1/§6.4 forbid it. This complements a generated
// child below a paramset: here the generate condition is above the paramset.
// The legal neighbor has the same forbidden association in an unselected arm.
// A.1.9: a paramset needs >= 1 paramset_item_declaration (corrected 2026-10-08)
//! lrm 6.4
//! lrm 6.3.1
//! lrm 6.3.1:2
//! reject-only E0926
`include "disciplines.vams"
module ps_dp_gen_card_top(p);
  inout p; electrical p;
  parameter integer choose_good = 0;
  if (choose_good) begin : good
    analog I(p) <+ 0.0;
  end else begin : bad
    ps_dp_gen_card u(p);
  end
endmodule
paramset ps_dp_gen_card ps_dp_gen_card_body;
  parameter real unused_item = 0;
  .gain = 2.0;
endparamset
module ps_dp_gen_card_body(p);
  inout p; electrical p;
  parameter real gain = 1.0;
  ps_dp_gen_card_leaf child(p);
  defparam child.gain = gain;
endmodule
module ps_dp_gen_card_leaf(p);
  inout p; electrical p;
  parameter real gain = 1.0;
  analog I(p) <+ gain * V(p);
endmodule
