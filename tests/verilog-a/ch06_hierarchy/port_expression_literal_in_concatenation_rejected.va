// §6.5.1 Port definition:
//
//   port ::= [ port_expression ] | . port_identifier ( [ port_expression ] )
//   port_expression ::= port_reference | { port_reference { , port_reference } }
//
//   "The port expression in the port definition can be one of the following:
//      A simple net identifier
//      A scalar member of a vector net or port declared within the module
//      A sub-range of a vector net or port declared within the module
//      A vector net formed as a result of the concatenation operator"
//
// Every alternative names NETS of the module: a concatenated port is a vector
// net built from port_references, each `port_identifier [ [ constant_range_
// expression ] ]`. A literal is not a port_reference — `1'b0` names no net of
// the module and nothing inside the module could ever read or drive it through
// this port — so `{a, 1'b0}` is none of the four forms.
//
// This is the tempting shape: in an INSTANCE's connection list (§6.5.4) a
// constant is a perfectly good actual for an input, and tying an unused bit of a
// concatenation to zero there is common. The port DEFINITION is the other side
// of the boundary, and §6.5.1 admits no expression there at all.
//
// `annex_a_syntax/concatenated_port.va` is the legal form, `{a, b}`, which
// runs and asserts that each member keeps its identity.
//
// EXACTLY ONE RULE IS BROKEN. The directives pin the parser's refusal and the
// literal it refused.
//
//! lrm 6.5.1
//! lrm 6.5.1:1
//! reject-only E0208
//! reject 1'b0
//! neighbour port_select_ordered_of_a_parent_port.va
`include "disciplines.vams"
module ch6_port_literal_member({a, 1'b0}, n);
  inout a, n;
  electrical a, n;
  analog I(a, n) <+ V(a, n);
endmodule
