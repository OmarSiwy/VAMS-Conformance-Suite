// §6.6.2, verbatim: "Named generate blocks may not have the same name as blocks
// in ANY OTHER GENERATE CONSTRUCT IN THE SAME SCOPE, EVEN IF NOT SELECTED FOR
// INSTANTIATION."
//
// The clause's preceding bullet licenses the opposite case — "it is permissible
// for more than one block within a SINGLE conditional generate construct to have
// the same name (since at most one is instantiated)" — and that half is
// generate_direct_nesting.va, which is the reading a broken elaborator also
// passes. This file is the prohibition. There are two if-generate constructs
// here, not one, so the permission does not reach them, and direct nesting does
// not either: that exception applies only when the inner construct is the sole
// item of an outer construct's block with no begin/end, which is not this shape.
//
// `if (0)` on the second construct is the point of the fixture, not an accident.
// A compiler that registered a block name only when its construct was selected
// would elaborate exactly one `b`, see no clash and accept — which is precisely
// what "even if not selected for instantiation" forbids. The name is declared by
// the TEXT of the construct, before any condition is evaluated.
//
// E0230 is that rule. Nothing in the check consults either condition, which is
// what "even if not selected" demands; what separates the two constructs from one
// is an identity stamped on the OUTERMOST enclosing construct, so the permitted
// case (two arms of one `if`, including an `else if` chain) shares it and these
// two do not.
//
//! lrm 6.6.2
//! lrm 6.6.2:2
//! lrm 6.8
//! lrm 6.8:1
//! reject-only E0230
//! neighbour generate_direct_nesting.va
`include "disciplines.vams"
module ch6_generate_block_name_collision(p);
  inout p; electrical p;
  generate
    if (1) begin : b
      localparam integer k = 1;
    end
    if (0) begin : b
      localparam integer k = 2;
    end
  endgenerate
  analog I(p) <+ V(p);
endmodule
