// §6.4.2: "If a paramset assigns a value to a module parameter and this value
// is outside the range specified for that module parameter, it shall be an
// error."
//
// The paramset assigns `.r = -1.0` to the module parameter
// `r = 1.0 from (0:inf)`: -1.0 is not in (0:inf). The paramset's own
// parameter s has no range and its default is used, so selection itself is
// unremarkable; the error is the module's range. The neighbour
// paramset_assigns_in_module_range.va differs only in the value, 2.0.
//
//! lrm 6.4.2
//! lrm 6.4.2:11
//! reject-only E0361
//! neighbour paramset_assigns_in_module_range.va
`include "disciplines.vams"
module b4_pmr_top(p, n);
  inout p, n; electrical p, n;
  b4_pmr_ps u(p, n);
endmodule

paramset b4_pmr_ps b4_pmr_res;
  parameter real s = 1.0;
  .r = -1.0;
endparamset

module b4_pmr_res(a, b);
  inout a, b; electrical a, b;
  parameter real r = 1.0 from (0:inf);
  analog I(a, b) <+ V(a, b) / r;
endmodule
