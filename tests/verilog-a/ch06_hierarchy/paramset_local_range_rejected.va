// §6.4.2: "When choosing an appropriate paramset, the following rules shall be
// enforced: ... The local parameters of the paramset, computed from
// parameters, shall be within the allowed ranges specified in the paramset."
//
// One paramset, whose local parameter is `twice = 2.0 * l from [0:2]`. The
// instance overrides l = 1.5, inside l's own range (0:inf), but
// twice = 2.0 * 1.5 = 3.0 is outside [0:2]. No paramset named b4_pli_ps is
// applicable, so the instance cannot be elaborated. The neighbour
// paramset_local_range_in_range.va differs only in the override, l = 0.75
// (twice = 1.5).
//
//! lrm 6.4.2
//! lrm 6.4.2:5
//! reject-only E0911
//! neighbour paramset_local_range_in_range.va
`include "disciplines.vams"
module b4_pli_top(p, n);
  inout p, n; electrical p, n;
  b4_pli_ps #(.l(1.5)) u(p, n);
endmodule

paramset b4_pli_ps b4_pli_dev;
  parameter real l = 1.0 from (0:inf);
  localparam real twice = 2.0 * l from [0:2];
  .k = 10.0;
endparamset

module b4_pli_dev(a, b);
  inout a, b; electrical a, b;
  parameter real k = 9.0;
  analog I(a, b) <+ k * V(a, b);
endmodule
