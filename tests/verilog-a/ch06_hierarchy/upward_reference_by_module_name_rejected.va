// §6.7.1: "Verilog-AMS HDL follows the rules for hierarchical upward
// referencing as described in 12.6 of IEEE Std 1364 Verilog with the addition
// that the scope_name shall be restricted to a hierarchical_inst_identifier."
//
// IEEE 1364-2005 12.6 spells the upward reference Syntax 12-7 as
// `upward_name_reference ::= module_identifier.item_name`: "A lower level
// module can reference items in a module above it in the hierarchy" by the
// NAME OF THE MODULE. The AMS addition narrows `scope_name` to a
// hierarchical_inst_identifier, an instance path, so a module identifier no
// longer qualifies.
//
// THE DESIGN. The kid is instantiated in `b4_mname_mid`, so that module is one
// level above the reference. The kid reads `b4_mname_mid.k`, the module-name
// spelling 12.6 permits and the addition removes; `k` is a parameter of the
// module, so the refusal is about the scope_name, not about the item.
//
// THE NEIGHBOUR upward_reference_by_instance_name.va is the same upward
// reference written the legal way: `sib.k`, where `sib` names an INSTANCE of
// the module two levels up. That one is retained by the restriction.
//
// There is no value to CHECK: the only observable is the diagnostic.
//
//! lrm 6.7.1
//! lrm 6.7.1:5
//! reject-only E0901
//! neighbour upward_reference_by_instance_name.va
`include "disciplines.vams"
module b4_mname_top(p);
  inout p; electrical p;
  b4_mname_mid m(p);
endmodule

module b4_mname_mid(p);
  inout p; electrical p;
  parameter real k = 2.5;
  b4_mname_kid u(p);
  analog I(p) <+ 0.0;
endmodule

module b4_mname_kid(p);
  inout p; electrical p;
  real kk;
  analog begin
    kk = b4_mname_mid.k;
    I(p) <+ kk * V(p);
  end
endmodule
