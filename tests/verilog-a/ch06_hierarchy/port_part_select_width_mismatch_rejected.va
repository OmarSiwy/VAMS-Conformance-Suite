// §6.5.7.1 "The sizes of the ports and net must match." A sub-range is
// §6.5.5's port expression, and its width is the number of members it names:
// d[5:4] is 2 nets, and the cell's port is [3:0], 4 wide. VerA refuses the
// connection with E0925 (Verilog-AMS keeps no truncate-or-extend rule for a
// port), and the cell's own reads of its port add nothing more.
// The neighbour connects a 4-wide part of a vector to the same kind of port.
//
//! lrm 6.5.7.1
//! lrm 6.5.7.1:1
//! reject-only E0925
//! reject the connection is 2 nets wide and the port it connects is 4
//! neighbour port_select_indexed_part_select.va
`include "disciplines.vams"
module ch6_pswm_top(p);
  inout p; electrical p;
  electrical [7:0] d;
  ch6_pswm_quad u(.w(d[5:4]), .c(p));    // illegal: 2 nets onto a 4-bit port
endmodule

module ch6_pswm_quad(w, c);
  inout [3:0] w; inout c;
  electrical [3:0] w; electrical c;
  analog begin
    V(w[3], c) <+ 0.5;
    V(w[0], c) <+ 0.25;
  end
endmodule
