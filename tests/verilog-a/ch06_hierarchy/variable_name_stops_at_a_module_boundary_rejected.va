// §6.8: "If an identifier is referenced directly (without a hierarchical path)
// within a named block or generate block, it shall be declared either locally
// or within a module or block higher in the same branch of the name tree. If
// declared locally, the local item shall be used; if not, the search continues
// upward until an item by that name is found or a module boundary is
// encountered. If the item is a variable, it shall stop at a module boundary;
// if the item is a named block or generate block, it continues to search
// higher-level modules until found."
//
// THE DESIGN. `b4_vstop_shared` is a variable of `b4_vstop_mid`, one module
// above the module holding the reference:
//
//   b4_vstop_top
//     m : b4_vstop_mid        real b4_vstop_shared;
//       u : b4_vstop_kid      analog begin : inner  r = b4_vstop_shared;  end
//
// The direct reference sits inside the kid's named block `inner`. The search
// goes block -> module, and there the item is a VARIABLE, so it stops at the
// kid's module boundary: `b4_vstop_mid` is beyond that boundary and its
// variable is not found. Nothing else in the kid or its blocks declares the
// name.
//
// THE NEIGHBOUR is the other half of the same sentence:
// generate_block_name_found_in_a_parent_module.va reads `gb.k` from a child,
// and `gb` is a generate block of the parent module, so that search DOES
// continue to the higher-level module and finds it.
//
// There is no value to CHECK: the only observable is the diagnostic.
//
//! lrm 6.8
//! lrm 6.8:5
//! reject-only E0314
//! neighbour generate_block_name_found_in_a_parent_module.va
`include "disciplines.vams"
module b4_vstop_top(p);
  inout p; electrical p;
  b4_vstop_mid m(p);
endmodule

module b4_vstop_mid(p);
  inout p; electrical p;
  real b4_vstop_shared;
  b4_vstop_kid u(p);
  analog begin
    b4_vstop_shared = 1.0;
    I(p) <+ 0.0;
  end
endmodule

module b4_vstop_kid(p);
  inout p; electrical p;
  analog begin
    begin : inner
      real r;
      r = b4_vstop_shared;
      I(p) <+ r * V(p);
    end
  end
endmodule
