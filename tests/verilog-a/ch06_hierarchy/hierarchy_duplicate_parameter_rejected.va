// IEEE1364-2005 12.2.2.2 and AMS6.3.3: once a named parameter is
// assigned a value, another assignment to that same name is forbidden.
// Only the duplicate association is invalid. The legal named association
// control is named_parameter_instantiation_unsupported.va (currently passes).
// Empty-association/default semantics have their own separate audit fixture.
//! lrm 6.3.3
//! lrm 6.3.3:3
// E0908 covers this repeated ordinary name as well as alias conflicts;
// this case has no aliasparam and isolates the ordinary-name prohibition.
//! reject-only E0908
//! neighbour named_parameter_instantiation_unsupported.va
`include "disciplines.vams"
module audit_hierarchy_duplicate_parameter_rejected(p);
  inout p; electrical p;
  audit_duplicate_leaf #(.gain(2.0),.gain(3.0)) u(p);
endmodule
module audit_duplicate_leaf(p);
  inout p; electrical p;
  parameter real gain=1.0;
  analog I(p)<+gain*V(p);
endmodule
