// AMS A.1.3's header requires its first parameter_declaration. #() has none.
// parameter_list_forms.va supplies a legal header and executes its parameters.
//! lrm A.1.3
//! lrm A.1.3:1000
//! reject-only E0246
//! neighbour parameter_list_forms.va
`include "disciplines.vams"
module parameter_list_empty_header #() (p);
  inout p; electrical p;
  analog I(p) <+ V(p);
endmodule
