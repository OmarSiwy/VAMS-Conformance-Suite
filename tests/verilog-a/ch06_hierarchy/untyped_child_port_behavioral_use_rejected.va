// §6.5.2.1, verbatim: "If the type of a port is not declared, the port can only
// be used in a structural description. (It can be passed to instances of
// modules, but cannot be accessed in a behavioral description.)" §3.6.2.4: "If
// the net is referenced in behavioral code, then it shall be treated as having
// no discipline with a domain binding of discrete".
//
// `c` is a port of the CHILD `untyped_leaf`, with a direction and no
// discipline, and the child's analog block probes and contributes it. The top
// binds it to its own `electrical p`, so the flattened node has a discipline;
// the rule is about the child's segment, which has none. The same leaf as the
// top module is untyped_port_behavioral_use_rejected.va, also E0337; an
// instance does not change what the child's source declares (#74).
//
// VerA refuses it with E0337, "`c` is a port of `untyped_leaf` with no
// discipline". The legal neighbour,
// untyped_child_port_passed_to_an_instance.va, gives the same undeclared port
// only a structural use, which §6.5.2.1 allows and §7.4 resolves.
//
//! lrm 6.5.2.1
//! lrm 3.6.2.4
//! lrm 3.6.2.4:4
//! reject-only E0337
//! neighbour untyped_child_port_passed_to_an_instance.va
`include "disciplines.vams"
module untyped_child_port_behavioral_use(p);
  inout p; electrical p;
  untyped_leaf u(p);
endmodule
module untyped_leaf(c);
  inout c;
  analog I(c) <+ V(c);
endmodule
