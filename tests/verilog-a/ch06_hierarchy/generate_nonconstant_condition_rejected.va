// §6.6: "all expressions in generate schemes shall be constant expressions,
// deterministic at elaboration time." Syntax 6-8 makes the loop condition a
// `genvar_expression`, whose leaves are `constant_primary` or `genvar_identifier`
// and nothing else — an `integer` variable is neither.
//
// This is the condition half of the rule; generate_nonconstant_init_rejected.va is
// the initialization half. Separated because they are separate diagnostics and a
// compiler can easily fold one and not the other: an elaborator that constant-folds
// the initial value but re-reads the condition each trip would pass that file and
// fail this one. `rv` is assigned in an analog block, so its value exists only at
// simulation time and the trip count is not determined before simulation begins.
//
// VerA reports it at the rule: E0418, "genvar loop condition is not a constant
// expression".
//
// The block body is an EMPTY `begin end`: Syntax 6-8's `generate_block ::=
// module_or_generate_item | begin [ : id ] { module_or_generate_item } end` admits no
// bare statement — a contribution is reachable only through `analog_construct ::=
// analog analog_statement` — so the `I(p) <+ V(p);` this file used to write there was
// a VerA parser extension, and a conforming compiler would have rejected the body
// and never evaluated the loop scheme the directive below pins.
//! lrm 6.6.1
//! lrm 6.6
//! lrm 6.6:2
//! reject-only E0418
`include "disciplines.vams"
module ch6_generate_nonconstant_condition(p);
  inout p; electrical p;
  integer rv;
  genvar i;
  analog rv = 1;
  generate
    for (i = 0; i < rv; i = i + 1) begin end
  endgenerate
endmodule
