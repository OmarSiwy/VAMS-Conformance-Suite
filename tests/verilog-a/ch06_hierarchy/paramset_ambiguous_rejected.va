// §6.4.2's terminal sentence: after the selection rules have kept the
// applicable paramsets and the three tie-breaking rules have been "applied in
// order until a unique paramset has been selected", "It shall be an error if
// there are still more than one applicable paramset for an instance after
// application of these rules."
//
// The two paramsets below are constructed to tie on every rule the clause
// lists. Both admit the instance (`l = 1.0` is inside both ranges, and `l` is a
// parameter of both); both leave zero parameters un-overridden (rule 1); both
// declare zero local parameters with specified ranges (rule 2); both
// specialize the same module, whose two ports the instance line connects in
// full, so zero ports are unconnected for either (rule 3). The language gives
// the elaborator no way
// to prefer one, and a compiler that silently takes the first — the behaviour
// this file pins out of existence — has invented a preference the clause
// explicitly makes an error.
//
// The `.k` values differ (10.0 vs 20.0) so the ambiguity is REAL: the two
// candidates would elaborate different devices, which is exactly why the
// clause refuses to guess.
//
//! lrm 6.4.2
//! lrm 6.4.2:10
//! reject-only E0914
//! neighbour paramset_tie_break_fewest_unoverridden.va
`include "disciplines.vams"
module ch6_amb_user(p, n);
  inout p, n; electrical p, n;
  ch6_amb_bin #(.l(1.0)) u(p, n);
endmodule

paramset ch6_amb_bin ch6_amb_base;
  parameter real l = 1.0 from [0.5:2.0];
  .k = 10.0;
endparamset

paramset ch6_amb_bin ch6_amb_base;
  parameter real l = 1.0 from [0.5:2.0];
  .k = 20.0;
endparamset

module ch6_amb_base(a, b);
  inout a, b; electrical a, b;
  parameter real k = 9.0;
  analog I(a, b) <+ k * V(a, b);
endmodule
