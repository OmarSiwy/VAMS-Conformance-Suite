// §6.2.2: "The list of module connections shall be provided only for modules
// defined with ports." The child is declared `module ch6_plmv_child;` — its
// port list is empty — but the instance supplies one ordered connection `(p)`.
// There is no port for that connection to attach to, so the source is refused
// with E0906, "declares 0 ports, and this instance connects 1".
//
// portless_instance_without_connections.va is the legal neighbour: the same
// child instantiated with the required empty parentheses and nothing inside.
//
//! lrm 6.2.2
//! lrm 6.2.2:1
//! reject-only E0906
//! neighbour portless_instance_without_connections.va
`include "disciplines.vams"
module ch6_plmv_top(p);
  inout p; electrical p;
  ch6_plmv_child u(p);
endmodule

module ch6_plmv_child;
endmodule
