// §6.6.2 instantiates the selected generate arm; §6.3.1/§6.4 then forbid a
// defparam in that instantiated paramset hierarchy. The paramset selects
// enabled=1, making the ordinary child and its defparam part of the hierarchy.
// The legal neighbor sets enabled=0 and executes the opposite arm instead.
// A.1.9: a paramset needs >= 1 paramset_item_declaration (corrected 2026-10-08)
//! lrm 6.4
//! lrm 6.3.1
//! lrm 6.3.1:2
//! reject-only E0926
`include "disciplines.vams"
module ps_dp_gen_child_top(p);
  inout p; electrical p;
  ps_dp_gen_child_card u(p);
endmodule
paramset ps_dp_gen_child_card ps_dp_gen_child_wrapper;
  parameter real unused_item = 0;
  .enabled = 1;
endparamset
module ps_dp_gen_child_wrapper(p);
  inout p; electrical p;
  parameter integer enabled = 0;
  if (enabled) begin : selected
    ps_dp_gen_child_body bad(p);
  end
  analog I(p) <+ 0.0;
endmodule
module ps_dp_gen_child_body(p);
  inout p; electrical p;
  ps_dp_gen_child_leaf child(p);
  defparam child.gain = 5.0;
endmodule
module ps_dp_gen_child_leaf(p);
  inout p; electrical p;
  parameter real gain = 1.0;
  analog I(p) <+ gain * V(p);
endmodule
