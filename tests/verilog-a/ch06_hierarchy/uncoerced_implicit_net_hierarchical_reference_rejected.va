// §6.7.1: "Hierarchical reference of an implicit net is allowed when the
// referenced net is first coerced to a specific discipline."
//
// The top's `implicit_link` is a §3.6.5 structural implicit net: it appears
// only as an actual on `u`'s first port. That port, `a`, has a direction but
// no discipline declaration (§6.5.2.1), and the child never uses it
// behaviorally, so nothing coerces the net. The top then reads the hierarchical
// name `u.a` in its own analog block, which designates that undisciplined
// implicit net; with no discipline there is no potential access and lowering
// refuses with E0901, "hierarchical name names nothing in the elaborated design".
//
// The legal neighbour implicit_net_hierarchical_reference_coerced.va is the
// same shape with the child's port declared electrical: the coercion the
// sentence requires happens, and the probe reads 1.25.
//
//! lrm 6.7.1
//! lrm 6.7.1:1001
//! reject-only E0901
//! neighbour implicit_net_hierarchical_reference_coerced.va
`include "disciplines.vams"
module ch6_implicit_uncoerced_top(n);
  inout n; electrical n;
  ch6_implicit_uncoerced_kid u(implicit_link, n);
  analog I(n) <+ V(u.a, n);
endmodule

module ch6_implicit_uncoerced_kid(a, b);
  inout a, b; electrical b;
  analog I(b) <+ V(b);
endmodule
