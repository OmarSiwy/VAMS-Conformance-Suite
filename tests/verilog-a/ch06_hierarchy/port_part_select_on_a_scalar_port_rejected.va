// §6.5.7.1 "A scalar port can be connected to a scalar net": a sub-range of
// two members is two nets, and a scalar port has room for one. VerA refuses
// `.v(d[1:0])` with E0925.
// The neighbour connects one member, `.v(r[i])`, to the same kind of port.
//
//! lrm 6.5.7.1
//! lrm 6.5.7.1:1
//! reject-only E0925
//! reject the connection is 2 nets wide and the port it connects is scalar
//! neighbour port_select_genvar_index.va
`include "disciplines.vams"
module ch6_psss_top(p);
  inout p; electrical p;
  electrical [1:0] d;
  ch6_psss_one u(.v(d[1:0]), .c(p));    // illegal: 2 nets onto a scalar port
endmodule

module ch6_psss_one(v, c);
  inout v, c; electrical v, c;
  analog V(v, c) <+ 0.5;
endmodule
