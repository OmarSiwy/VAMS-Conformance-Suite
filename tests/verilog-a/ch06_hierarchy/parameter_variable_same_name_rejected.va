// §6.8: "An identifier shall be used to declare only one item within a scope."
// duplicate_declaration_rejected.va pins two VARIABLES; the sentence says ITEM,
// and a parameter and a net are items of the module scope as much as a variable
// is (§6.8 lists what opens a new scope — modules, named blocks, analog
// functions, generate blocks — and a second declaration is not on it).
//
// A parameter and a variable named `k` in one module: two kinds of item, one
// identifier. Renaming the variable makes the file legal.
//
//! lrm 6.8
//! lrm 6.8:1
//! reject-only E0362
`include "disciplines.vams"
module ch6_parameter_variable_same_name(p);
  inout p; electrical p;
  parameter real k = 1.0;
  real k;
  analog I(p) <+ V(p);
endmodule
