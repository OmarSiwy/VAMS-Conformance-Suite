// §6.5 Ports:
//
//   "Ports provide a means of interconnecting instances of modules. If a module
//    A instantiates module B, THE PORTS OF MODULE B ARE ASSOCIATED WITH EITHER
//    THE PORTS OR THE INTERNAL NETS OF MODULE A."
//
// Below, A (`ch6_port_var_top`) connects B's `electrical` port to `r`, a `real`
// VARIABLE of A. A variable is neither a port nor an internal net of A: it has a
// value, but no node — nothing for B's port to be associated with, no potential
// for B's `V(a)` to read and nowhere for B's `I(a) <+` to send current.
//
// It is also not an implicit net (§3.6.5 creates one only for a name that is NOT
// otherwise declared, and `r` is declared). A compiler that treated it as one
// used to create a fresh node named `r` next to the variable of the same name —
// the design compiled, B's conductance hung off a node nothing else could see,
// and the variable `r` was silently disconnected from the port it was written
// into.
//
// Only a port of CONTINUOUS discipline is the subject: a real value driving a
// `wreal` or discrete input is §3.7's "real expression", and is legal.
//
// EXACTLY ONE RULE IS BROKEN: connect B to `p` (a port of A) or to an
// `electrical` net declared in A and the design is legal.
//
//! lrm 6.5
//! reject-only E0906
//! reject is a variable
`include "disciplines.vams"
module ch6_port_var_top(p);
  inout p; electrical p;
  real r;
  ch6_port_var_child c(r);
  analog begin
    r = 1.0;
    I(p) <+ V(p);
  end
endmodule

module ch6_port_var_child(a);
  inout a; electrical a;
  analog I(a) <+ V(a);
endmodule
