// AMS A.4.1 gives two separate list alternatives: all ordered or all named.
// IEEE 1364-2005 §12.2.2 states the same prohibition. The first value here is
// ordered and the second named; parameter_list_forms.va executes each legal
// form in a separate instance, including a named empty value.
//! lrm A.4.1
//! lrm A.4.1:1000
//! reject-only E0246
//! neighbour parameter_list_forms.va
`include "disciplines.vams"
module parameter_list_mixed_leaf(p);
  inout p; electrical p;
  parameter real a=3,b=7;
  analog I(p) <+ (a+b)*V(p);
endmodule
module parameter_list_mixed_override(p);
  inout p; electrical p;
  parameter_list_mixed_leaf #(2,.b(4)) child(p);
endmodule
