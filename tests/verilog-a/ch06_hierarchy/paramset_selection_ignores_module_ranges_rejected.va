// §6.4.2: "If a paramset assigns a value to a module parameter and this value
// is outside the range specified for that module parameter, it shall be an
// error. The simulator shall consider only the ranges of the paramset's own
// parameters when choosing a paramset."
//
// Two paramsets named b4_psm over one module b4_psm_res (r = 1.0 from (0:inf)):
//   A: parameter l in [0:2];                         assigns .r = -1.0
//   B: parameter l in [0:2], parameter extra = 0.0;  assigns .r = 1.0
// The instance overrides l = 1.0 only.
//
// Choosing on the paramsets' own ranges, both are applicable, and tie rule 1
// ("the fewest number of un-overridden parameters": A 0, B 1) selects A. A
// then assigns -1.0 to a parameter whose range is (0:inf), which is the error
// of the first sentence. An implementation that let the MODULE's range steer
// selection would drop A, select B and compile; the second sentence forbids
// that, so the design is refused. The neighbour
// paramset_selection_by_paramset_ranges.va differs only in A's value, 2.0,
// and shows A is the paramset selected.
//
// The second sentence is a positive selection rule. The named assertion
// test_paramset_selection_uses_only_paramset_ranges pairs this exclusive
// refusal with the legal neighbour's numeric checks; the refusal alone is
// evidence for the out-of-range prohibition, not for that positive sentence.
//
//! lrm 6.4.2
//! lrm 6.4.2:11
//! reject-only E0361
//! neighbour paramset_selection_by_paramset_ranges.va
`include "disciplines.vams"
module b4_psm_top(p, n);
  inout p, n; electrical p, n;
  b4_psm #(.l(1.0)) u(p, n);
endmodule

paramset b4_psm b4_psm_res;   // A: selected, and assigns outside the module's range
  parameter real l = 1.0 from [0:2];
  .r = -1.0;
endparamset

paramset b4_psm b4_psm_res;   // B: one un-overridden parameter
  parameter real l = 1.0 from [0:2];
  parameter real extra = 0.0;
  .r = 1.0;
endparamset

module b4_psm_res(a, b);
  inout a, b; electrical a, b;
  parameter real r = 1.0 from (0:inf);
  analog I(a, b) <+ V(a, b) / r;
endmodule
