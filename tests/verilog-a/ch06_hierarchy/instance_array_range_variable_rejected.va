// §6.2.2's instance array range is annex A's
// `range ::= [ msb_constant_expression : lsb_constant_expression ]`: one
// instance per element, so both bounds are needed while the instance tree is
// built. `k` is an `integer` variable, which is not a constant expression
// (§3.4 admits constant numbers and parameters), whatever it is assigned.
//
// instance_array_range_over_parameter.va is the legal neighbour, the same
// range written over a parameter.
//
//! lrm 6.2.2
//! lrm 6.2.2:1004
//! reject-only E0909
//! neighbour instance_array_range_over_parameter.va
`include "disciplines.vams"
module ch6_iarv_parent(p, n);
  inout p, n; electrical p, n;
  integer k;
  ch6_iarv_kid u[k:0](p, n);
  analog k = 1;
endmodule

module ch6_iarv_kid(a, b);
  inout a, b; electrical a, b;
  analog I(a, b) <+ V(a, b);
endmodule
