// §6.4 permits chains but still forbids a defparam under the associated module.
// The near link deliberately has no .parameter assignment, so this tests no
// unspecified precedence between two links. The far link reaches a module
// containing defparam. paramset_chain.va is the behavioral legal chain.
// A.1.9: a paramset needs >= 1 paramset_item_declaration (corrected 2026-10-08)
//! lrm 6.4
//! lrm 6.3.1
//! lrm 6.3.1:2
//! reject-only E0926
//! neighbour paramset_chain.va
`include "disciplines.vams"
module ps_dp_chain_top(p);
  inout p; electrical p;
  ps_dp_chain_near u(p);
endmodule
paramset ps_dp_chain_near ps_dp_chain_far;
  real tag;
  tag = 1.0;
endparamset
paramset ps_dp_chain_far ps_dp_chain_body;
  parameter real unused_item = 0;
  .gain = 2.0;
endparamset
module ps_dp_chain_body(p);
  inout p; electrical p;
  parameter real gain = 1.0;
  ps_dp_chain_leaf child(p);
  defparam child.gain = gain;
endmodule
module ps_dp_chain_leaf(p);
  inout p; electrical p;
  parameter real gain = 1.0;
  analog I(p) <+ gain * V(p);
endmodule
