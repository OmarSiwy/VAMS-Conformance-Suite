// §6.5.5's "scalar member" is a member of a VECTOR net (§6.5.1: "A scalar
// member of a vector net or port declared within the module"). `s` is
// declared without a range, so `s[0]` selects from a net that has no
// elements: VerA refuses it with E0351 instead of joining the port to an
// undeclared net named `s[0]`.
// The neighbour connects members of a declared vector.
//
//! lrm 6.5.5
//! lrm 6.5.1
//! reject-only E0351
//! reject `s` was not declared with a range
//! neighbour port_select_genvar_index.va
`include "disciplines.vams"
module ch6_pssc_top(p);
  inout p; electrical p;
  electrical s;
  ch6_pssc_one u(.v(s[0]), .c(p));    // illegal: s is scalar
endmodule

module ch6_pssc_one(v, c);
  inout v, c; electrical v, c;
  analog V(v, c) <+ 0.5;
endmodule
