// §6.3 requires selection to use the defparam value; §6.4.2 then admits no
// member for w=20, outside both [0:4) and [4:10]. Inline w=2 cannot rescue
// this instance. The precedence fixture's w=7 is the behavioral legal neighbor.
//! lrm 6.3
//! lrm 6.4.2
//! lrm 6.4.2:4
//! reject E0911
`include "disciplines.vams"
module ps_outer_range_top(p);
  inout p; electrical p;
  ps_outer_range_card #(.w(2.0)) u(p);
  defparam u.w=20.0;
endmodule
paramset ps_outer_range_card ps_outer_range_leaf;
  parameter real w=1.0 from [0:4);
  .gain=2.0*w;
endparamset
paramset ps_outer_range_card ps_outer_range_leaf;
  parameter real w=0.0 from [4:10];
  .gain=3.0*w;
endparamset
module ps_outer_range_leaf(p);
  inout p; electrical p;
  parameter real gain=1.0;
  analog I(p) <+ gain*V(p);
endmodule
