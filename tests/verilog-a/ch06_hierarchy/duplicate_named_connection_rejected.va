// §6.2.2 named port connections, held to the rule of the base standard the
// clause builds on: IEEE 1364-2005 §12.3.6 connects each named port "to the
// expression in parentheses following its name", and a name that appears TWICE
// in one connection list gives the port two expressions — a connection the
// grammar has no meaning for, since one port joins one net (§6.5). VerA used to
// resolve a named connection by first match, so the second `.a(...)` below
// vanished without a trace: the instance linted clean, `a` bound to `p`, and
// the contradictory `.a(n)` was silently discarded — a dropped connection in a
// netlist, which is the worst kind of clean.
//
// The list is otherwise well-formed (every name is a port, the list is all
// named, `.b(n)` is fine), so the ONE diagnosable defect is the duplicate and
// the reject substrings pin exactly it.
//
//! lrm 6.2.2
//! reject-only E0906
//! reject connected twice
`include "disciplines.vams"
module ch6_dup_conn_parent(p, n);
  inout p, n; electrical p, n;
  ch6_dup_conn_kid u(.a(p), .a(n), .b(n));
endmodule

module ch6_dup_conn_kid(a, b);
  inout a, b; electrical a, b;
  analog I(a, b) <+ V(a, b);
endmodule
