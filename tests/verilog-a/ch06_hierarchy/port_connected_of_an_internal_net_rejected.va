// §6.5.6 Detecting port connections:
//
//   "When a module is instantiated, all of its PORTS need not be connected. ...
//    In some cases, it may be important to know whether a particular PORT is
//    connected. ... The $port_connected() function described in 9.19 can be used
//    to determine whether a port is connected."
//
// §9.19 fixes the operand:
//
//   "The $port_connected() function takes one argument, WHICH MUST BE A PORT
//    IDENTIFIER. The return value shall be one (1) if the port was connected to
//    a net (by order or by name) when the module was instantiated, and zero (0)
//    otherwise."
//
// `q` below is an INTERNAL net: declared `electrical` in the module body but not
// in the port list, so no instantiation can connect it or leave it
// unconnected, and "was it connected when the module was instantiated" has no
// answer. It is the natural mistake — `q` is a net, and a net is what a port
// connects to — which is why the rule is stated about the port identifier and
// not about the kind of object.
//
// `port_connected.va` is the legal form and asserts both answers.
//
// EXACTLY ONE RULE IS BROKEN: `$port_connected(p)` in the same place compiles.
//
//! lrm 6.5.6
//! lrm 6.5.6:2
//! lrm 9.19
//! lrm 9.19:5
//! reject-only E0822
//! reject requires a port identifier
//! neighbour port_connected.va
`include "disciplines.vams"
module ch6_port_connected_internal(p);
  inout p; electrical p;
  electrical q;
  analog begin
    I(q) <+ V(q);
    I(p) <+ $port_connected(q) * V(p);
  end
endmodule
