// §3.4.5 forbids directly overriding a localparam with defparam. The binding
// is outside the paramset hierarchy, but its target still cannot be changed.
// The runtime defaults fixture overrides w and recomputes a dependent local
// parameter legally; it never assigns the local parameter directly.
//! lrm 3.4.5
//! lrm 3.4.5:1000
//! reject E0911
`include "disciplines.vams"
module ps_outer_local_top(p);
  inout p; electrical p;
  ps_outer_local_card u(p);
  defparam u.fixed=7.0;
endmodule
paramset ps_outer_local_card ps_outer_local_leaf;
  parameter real w=1.0;
  localparam real fixed=2.0*w;
  .gain=fixed;
endparamset
module ps_outer_local_leaf(p);
  inout p; electrical p;
  parameter real gain=1.0;
  analog I(p) <+ gain*V(p);
endmodule
