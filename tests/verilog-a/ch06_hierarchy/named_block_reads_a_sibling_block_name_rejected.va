// §6.8: "If an identifier is referenced directly (without a hierarchical path)
// within a named block or generate block, it shall be declared either locally
// or within a module or block higher in the same branch of the name tree."
//
// The bare `h` in block `b` is declared only in block `a`. Block a is a
// sibling of b, not higher in b's branch of the name tree (module -> b), and
// nothing named h is declared in b or in the module. So the reference breaks
// the rule. (§5.3.2 would let `a.h` reach it with a hierarchical path; the
// rule is about the direct reference.)
//
// The neighbour named_block_reads_a_module_variable.va moves the one
// declaration `real h;` from block a to the module, which is on b's branch,
// and compiles.
//
//! lrm 6.8
//! lrm 6.8:3
//! reject-only E0314
//! neighbour named_block_reads_a_module_variable.va
`include "disciplines.vams"
module b4_nbs(p);
  inout p; electrical p;
  analog begin
    begin : a
      real h;
      h = V(p);
    end
    begin : b
      real r;
      r = h;
      I(p) <+ r;
    end
  end
endmodule
