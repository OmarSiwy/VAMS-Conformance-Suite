// §6.5.2.2: "A port can be declared in both a port type declaration and a port
// direction declaration. If a port is declared as a vector, the range
// specification between the two declarations of a port shall be identical."
//
// THIS REJECTION IS CORRECT CONFORMANCE, and this file used to say the opposite.
// The source is now the clause's own printed error case, transcribed: the LRM
// writes `input [3:0] in; electrical [0:3] in;` and labels it "error, MSB and LSB
// in the port type declaration does not evaluate to the same value as the port
// direction declaration". Only the direction keyword and the identifier differ
// here; the ranges are `[3:0]` against `[0:3]`, reversed, exactly as printed.
//
// It used to write `inout p; electrical [3:0] p;` — a range on ONE declaration
// only — and claim that was the clause's third example. It is not: all three
// examples the LRM prints carry a range on both lines, and the rule's own sentence
// is guarded by "IF a port is declared as a vector", so a missing range is a
// different and arguably permissive shape that has to be inferred from IEEE 1364
// rather than read out of this clause. Writing the LRM's own case costs nothing
// and makes the fixture portable.
//
// It used to reach the verdict by a different road, and this paragraph used to
// say so: VerA's parser took no range on a port DIRECTION declaration, so the
// `[` in `inout [3:0] p` was a parse boundary (E0208, "expected an identifier")
// and the two ranges were never compared. It also said what to do about that —
// "the day ranged port declarations parse, this fixture must keep failing, and
// it will then be the §6.5.2.2 comparison that fails it, with a different code".
// That day arrived. Both declarations now parse, both ranges are FOLDED, and
// E0350 is the comparison itself: `[3:0]` against `[0:3]`, reported as the rule
// and not as a syntax limit.
//
// Its sibling vector_ports_range_equal.va is the other half of the same clause —
// the pair the LRM calls VALID, `[0:3]` against `[0:4-1]` — and it now runs
// green, which is what makes this file's rejection mean anything: the two
// differ only in whether the folded bounds agree.
//
//! lrm 6.5.2.2
//! lrm 6.5.2.2:2
//! reject-only E0350
//! neighbour vector_ports_range_equal.va
`include "disciplines.vams"
module ch6_vector(p);
  inout [3:0] p; electrical [0:3] p;
  analog begin I(p[0]) <+ V(p[1]); I(p[2]) <+ V(p[3]); end
endmodule
