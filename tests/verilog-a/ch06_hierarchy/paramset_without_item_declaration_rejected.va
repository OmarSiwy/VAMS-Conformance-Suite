// Syntax 6-4 (A.1.9):
//
//   paramset_declaration ::=
//       { attribute_instance } paramset paramset_identifier module_or_paramset_identifier ;
//           paramset_item_declaration { paramset_item_declaration }
//           paramset_statement { paramset_statement }
//       endparamset
//
// The item list is `x { x }`: at least one paramset_item_declaration (a
// parameter, local parameter, aliasparam, integer or real declaration) before
// the statements. The paramset below has only a statement, `.k = 2.0;`, so it
// is not a paramset_declaration. Everything else is legal: the module exists,
// `k` is its parameter, and the instance names the paramset.
//
// The neighbour paramset_with_one_item_declaration.va is this file with one
// `parameter real unused_item = 0;` in the body, and compiles.
//
//! lrm A.1.9
//! lrm 6.4
//! reject-only E0297
//! neighbour paramset_with_one_item_declaration.va
`include "disciplines.vams"
module ch6_noitem_top(p, n);
  inout p, n; electrical p, n;
  ch6_noitem_ps u(p, n);
endmodule

paramset ch6_noitem_ps ch6_noitem_dev;
  .k = 2.0;
endparamset

module ch6_noitem_dev(a, b);
  inout a, b; electrical a, b;
  parameter real k = 1.0;
  analog I(a, b) <+ k * V(a, b);
endmodule
