// §6.2.1 Top-level modules and $root:
//
//   "The name $root is used to unambiguously refer to a TOP-LEVEL INSTANCE or
//    to an instance path starting from the root of the instantiation tree.
//    $root is the root of the instantiation tree.
//        $root.A.B       // item B within top instance A"
//
// and the clause's reason for having the prefix at all is that it switches OFF
// the local-first search: "A.B.C can mean the local A.B.C or the top-level
// A.B.C ... The ambiguity is resolved by giving priority to the local scope ...
// $root allows explicit access to the top level in those cases".
//
// So after `$root.` the first name must be a TOP-LEVEL instance. Below, the
// mid-level module has a LOCAL child instance `u` — so the unprefixed `u.gain`
// would resolve, to 5.0 — but the design's only top-level instance is
// `ch6_root_noinst_top` (§6.2.1: top-level modules are those "that do not appear
// in any module instantiation statement"), and nothing named `u` hangs from the
// root. `$root.u.gain` therefore names nothing, and a compiler that quietly fell
// back to the local `u` would be doing exactly what the prefix exists to
// prevent.
//
// `root_reference_unsupported.va` is the legal pair: `u.gain` locally and
// `$root.ch6_root_top.u.gain` from the root, asserted to differ.
//
// EXACTLY ONE RULE IS BROKEN: drop the `$root.` and the path resolves locally.
//
//! lrm 6.2.1
//! lrm 6.7
//! lrm 6.2.1:1000
//! reject-only E0901
//! reject names nothing in the elaborated design
//! neighbour root_reference_unsupported.va
`include "disciplines.vams"
module ch6_root_noinst_top(p, n);
  inout p, n; electrical p, n;
  ch6_root_noinst_mid mid(p, n);
endmodule

module ch6_root_noinst_mid(a, b);
  inout a, b; electrical a, b;
  ch6_root_noinst_leaf #(.gain(5.0)) u(a, b);
  analog I(a, b) <+ 0.0 * $root.u.gain * V(a, b);
endmodule

module ch6_root_noinst_leaf(a, b);
  inout a, b; electrical a, b;
  parameter real gain = 1.0;
  analog I(a, b) <+ gain * V(a, b);
endmodule
