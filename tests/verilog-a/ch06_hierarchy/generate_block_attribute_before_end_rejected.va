// §2.9: "An attribute_instance can appear in the Verilog-AMS description as a
// prefix attached to a declaration, a module item, a statement, or a port
// connection." Syntax 6-8: `generate_block ::= module_or_generate_item | begin
// [ : generate_block_identifier ] { module_or_generate_item } end`.
//
// The block below closes properly, but its `(* a *)` comes after the block's
// only item and right before `end`: nothing follows it for it to prefix. That
// is E0207 ("an attribute instance prefixes nothing"), the code the same
// instance gets before end of file at the top level
// (ieee1364/03_lexical_conventions/dangling_attribute_rejected.v) or
// before `endmodule`. Before #49 the generate block dropped it silently.
// Nothing else in the source is wrong, so E0207 is the only error.
//
// Legal neighbour: generate_block_attribute_then_end.va, the same block with
// its attribute prefixing the analog construct.
//
//! lrm 2.9
//! reject-only E0207
//! neighbour generate_block_attribute_then_end.va
`include "disciplines.vams"
module ch6_gen_attr_before_end(p);
  inout p; electrical p;
  if (1) begin analog I(p) <+ V(p); (* a *) end
endmodule
