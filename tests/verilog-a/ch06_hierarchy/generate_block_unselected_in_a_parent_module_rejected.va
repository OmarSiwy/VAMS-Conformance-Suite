// §6.6.2: "Conditional generate constructs select at most one generate block
// from a set of alternative generate blocks", and a block the scheme does not
// select is not instantiated, so nothing names it. §6.8 (IEEE 1364-2005 12.7)
// searches "first at the current level and then in higher level modules until
// found" for a path that starts with a generate block name.
//
// THE DESIGN. generate_block_name_found_in_a_parent_module.va with the
// if-generate's condition 0 instead of 1. The top's generate block gb, and its
// localparam k, are never instantiated, so the child's `gb.k` names nothing:
// the upward search finds the block's declaration and the scheme deselects it.
// That file is the legal neighbour: the same reference to a selected block
// reads 2.5.
//
//! lrm 6.6.2
//! lrm 6.8
//! lrm 6.8:1001
//! reject-only E0901
//! neighbour generate_block_name_found_in_a_parent_module.va
`include "disciplines.vams"
module ch6_gbu_top(p, n);
  inout p, n; electrical p, n;
  generate
    if (0) begin : gb
      localparam real k = 2.5;
    end
  endgenerate
  ch6_gbu_kid u(p, n);
endmodule

module ch6_gbu_kid(a, b);
  inout a, b; electrical a, b;
  real kk;
  analog begin
    kk = gb.k;
    I(a, b) <+ kk * V(a, b);
  end
endmodule
