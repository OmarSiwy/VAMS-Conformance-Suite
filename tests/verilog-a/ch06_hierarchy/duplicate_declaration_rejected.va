// §6.8's only prohibition, verbatim: "An identifier shall be used to declare only
// one item within a scope. This rule means it is ILLEGAL TO DECLARE TWO OR MORE
// VARIABLES WHICH HAVE THE SAME NAME, or to name a task the same as a variable
// within the same module, or to give an instance the same name as the name of the
// net connected to its output."
//
// Two `real value;` lines in one module body is the first clause of that sentence,
// written as plainly as it can be written. The module scope is one scope (§6.8
// lists what opens a new one: modules, named blocks, analog functions, generate
// blocks — not a second declaration), so both declarations land in it and the
// identifier declares two items.
//
// This is the half of §6.8 nothing tested: local_scope_shadow.va and
// local_scope_declaration_shadow.va both exercise the LEGAL side, where an inner
// scope reuses a name the outer scope also declares. That is legal precisely
// because the two names are in different scopes; this file is what pins the
// boundary between the two cases, and without it a compiler with no scope table at
// all — one map, last writer wins — passes both shadow fixtures.
//
// The reject line is E0362, the code for this rule, as this header asked for
// while the generic `DiagnosticsReported` stood in for it. The check is over ONE
// DECLARATION LIST, which is what keeps the two shadow fixtures above legal: a
// list is the declarations of a single scope, so an inner scope reusing an outer
// name never reaches it.
//
//! lrm 6.8
//! lrm 6.8:1
//! lrm 6.8:2
//! reject-only E0362
//! neighbour local_scope_declaration_shadow.va
//! neighbour local_scope_shadow.va
`include "disciplines.vams"
module ch6_duplicate_declaration(p);
  inout p; electrical p;
  real value;
  real value;
  analog begin
    value = 1.0;
    I(p) <+ value * V(p);
  end
endmodule
