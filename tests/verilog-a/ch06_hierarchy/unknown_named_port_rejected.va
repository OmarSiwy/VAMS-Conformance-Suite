// §6.5.5: "The port name shall be the name specified in the module
// definition." The child defines only the port `a`; the named connection
// `.nope(p)` names something the module definition never declared, so the
// connection corresponds to no port. VerA reports E0906, "`nope` is not a port
// of `ch6_unn_kid`".
//
// named_port_expressions.va is the legal neighbour, every named connection
// naming a port the child actually declares.
//
//! lrm 6.5.5
//! lrm 6.5.5:1
//! reject-only E0906
//! neighbour named_port_expressions.va
`include "disciplines.vams"
module ch6_unn_top(p);
  inout p; electrical p;
  ch6_unn_kid u(.nope(p));
endmodule

module ch6_unn_kid(a);
  inout a; electrical a;
  analog I(a) <+ 0.0;
endmodule
