// §6.6.1, verbatim: "The genvar is used as an integer during elaboration to
// evaluate the generate loop and create instances of the generate block, but IT
// DOES NOT EXIST AT SIMULATION TIME. A GENVAR SHALL NOT BE REFERENCED ANYWHERE
// OTHER THAN IN A LOOP GENERATE SCHEME."
//
// `i` is declared as a genvar and then read in an analog block, which is
// simulation time. There is nothing for the reference to resolve to — the object
// was consumed by elaboration — so a conforming compiler diagnoses it and there is
// no `//! xfail`.
//
// The diagnostic arrives from an adjacent direction and that is worth writing
// down: VerA never puts a genvar into the analog scope, so the read is E0314,
// "unknown identifier: `i`", rather than a rule that names genvars. Same verdict,
// and the same verdict a compiler with no genvar concept at all would give — which
// is why the fixture's value is the requirement it records, not the code it pins.
// The complementary case, a genvar read INSIDE the loop generate block, is legal
// and different: §6.6.1 puts an implicit localparam of the same name there, and
// generate_implicit_localparam.va covers it.
//
//! lrm 6.6.1
//! lrm 6.6.1:2
//! reject-only E0314
//! neighbour generate_implicit_localparam.va
`include "disciplines.vams"
module ch6_genvar_outside_loop(p);
  inout p; electrical p;
  genvar i;
  analog I(p) <+ i * V(p);
endmodule
