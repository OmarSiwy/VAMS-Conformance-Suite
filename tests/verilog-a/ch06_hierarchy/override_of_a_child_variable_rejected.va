// §6.3 Overriding module parameter values:
//
//   "When one module instantiates another, it can alter the values of any
//    PARAMETERS declared within the instantiated module, as well as the values
//    of various system parameters implicitly declared for all modules. There
//    are three ways to alter parameter values: defparam statement ... Module
//    instance parameter value assignment ... paramset."
//
// and §6.3.3 says what the name in a by-name assignment must be: "The name
// shall be the name specified in the instantiated module" — the name of a
// parameter it declares.
//
// What the instantiating module may alter is a PARAMETER. `x` below is declared
// in the child, so the name is "specified in the instantiated module" — this is
// not the misspelling `hierarchy_empty_unknown_rejected.va` pins — but it
// is a `real` VARIABLE, whose value is computed by the child's analog block and
// has no declaration default for an instantiation to replace. None of §6.3's
// three mechanisms reaches it.
//
// EXACTLY ONE RULE IS BROKEN: `#(.gain(2.0))` in the same place is legal
// (`defparam_precedence_over_instance_override.va` overrides `gain` both ways).
//
//! lrm 6.3
//! lrm 6.3.3
//! lrm 6.3.3:1
//! reject-only E0907
//! reject is not a parameter of
//! neighbour defparam_precedence_over_instance_override.va
`include "disciplines.vams"
module ch6_override_variable_top(p);
  inout p; electrical p;
  ch6_override_variable_child #(.x(2.0)) u(p);
endmodule

module ch6_override_variable_child(a);
  inout a; electrical a;
  parameter real gain = 1.0;
  real x;
  analog begin
    x = gain * V(a);
    I(a) <+ x;
  end
endmodule
