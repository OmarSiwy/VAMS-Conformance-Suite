// §6.6.1, verbatim: "Both the initialization and iteration assignments in the loop
// generate scheme shall assign to the same genvar." The init here assigns `i`, the
// iteration assigns `j`, and both are genvars — so this is NOT the
// constant-expression rule its two siblings pin. `j` is a perfectly legal
// `genvar_primary` in Syntax 6-8's `genvar_expression`; what the LRM forbids is the
// assignment TARGET, not the shape of the expression. The header of this file used
// to say "`j` in the step is not a constant expression of `i`", which conflated the
// two rules, and it carried a leftover `// EXPECT: error --` sidecar line from the
// suite that preceded `//!` directives. Both are gone.
//
// THE SOURCE VIOLATES A SECOND BULLET AND THAT IS UNAVOIDABLE, so it is written down
// rather than glossed. Because the iteration assigns `j`, the condition variable `i`
// never advances, so the loop also fails "It shall be an error if the loop generate
// scheme does not terminate". There is no source that breaks the same-genvar rule
// alone: put the condition on `j` instead and `j` has no initialization, which
// breaks the constant-expression rule in its place. A conforming compiler may report
// either bullet; both are §6.6.1, which is what the `//! lrm` line cites.
//
// VerA's ordering IS stable, which is why the specific code is still pinned rather
// than relaxed to `DiagnosticsReported`: ir/lower.zig:2184 takes the genvar from the
// init, then on the FIRST trip constant-folds the step's value `j + 1`, finds `j`
// unbound and reports E0419 — long before the 4096-iteration cap that would produce
// E0420. E0419's title names the adjacent constant-expression rule ("genvar loop step
// is not a constant expression"), but its explain text quotes this bullet, so the
// code does identify the right sentence.
//
// The body is an EMPTY `begin end`. Syntax 6-8 is `generate_block ::=
// module_or_generate_item | begin [ : id ] { module_or_generate_item } end`, and a
// contribution statement is neither — it is reachable only through
// `analog_construct ::= analog analog_statement`. This file used to write a bare
// `I(p) <+ i * V(p);` there, a VerA parser extension that a conforming compiler
// rejects at the body, never reaching the loop scheme at all.
//
//! lrm 6.6.1
//! reject-only E0419
`include "disciplines.vams"
module ch6_generate_mismatched_genvar(p);
  inout p; electrical p; genvar i, j;
  generate
    for (i = 0; i < 2; j = j + 1) begin end
  endgenerate
  analog I(p) <+ V(p);
endmodule
