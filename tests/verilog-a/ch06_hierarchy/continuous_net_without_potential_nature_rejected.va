// §6.5.8: "A net of continuous discipline shall have a potential nature and
// may have a flow nature."
//
// Annex D's `current` is a continuous discipline binding only a flow nature, so
// `ionly` — a net of it — has no potential nature at all. The flow half of the
// sentence is satisfied (there is a flow to access); the potential half is not,
// and `V(ionly)` names a potential the net does not have. Lowering refuses it
// with E0501 whose note is "binds no potential nature" — the rule itself, not a
// §4.4 name mismatch, because `V` is exactly annex D's access spelling for a
// potential nature and the discipline binds none to mismatch against.
//
// The net is internal rather than a port because §6.5.2's E0360 would otherwise
// refuse an `inout` port of a signal-flow discipline first, hiding this rule
// behind another one. The conservative contribution on (p, n) is there only so
// the module is a well-formed device.
//
// The neighbour hierarchy_overview_instances_and_overrides.va is the legal
// reading of the sentence on ordinary electrical nets — a continuous
// discipline WITH a potential nature, every V() access accepted and asserted.
//
//! lrm 6.5.8
//! lrm 6.5.8:1
//! reject-only E0501
//! neighbour hierarchy_overview_instances_and_overrides.va
`include "disciplines.vams"
module ch6_continuous_net_without_potential_nature(p, n);
  inout p, n; electrical p, n;
  current ionly;
  analog begin
    V(ionly) <+ 1.0;
    I(p, n) <+ V(p, n) * 1.0e-3;
  end
endmodule
