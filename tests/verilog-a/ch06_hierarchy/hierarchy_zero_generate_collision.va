// IEEE1364-2005 12.4.1 / AMS6.6.1: the named array is declared even
// when no iterations instantiate. Thus real empty conflicts with begin:empty.
// Legal counterpart hierarchy_zero_generate_control.va uses real value.
//! lrm 6.6.1
//! lrm 6.8
//! lrm 6.6.1:5
//! lrm 6.6.1:1003
//! lrm 6.8:1
//! reject-only E0230
//! neighbour hierarchy_zero_generate_control.va
`include "disciplines.vams"
module audit_hierarchy_zero_generate_collision(p);
  inout p; electrical p;
  real empty;
  genvar i;
  generate
    for(i=0;i<0;i=i+1) begin:empty
      analog I(p)<+100.0*V(p);
    end
  endgenerate
  analog begin
    empty=2.0;
    I(p)<+empty*V(p);
  end
endmodule
