// §6.6.1: "The loop index variable shall be declared in a genvar declaration
// prior to its use." The loop below writes `i` in all three positions but no
// `genvar i;` is in scope — `i` is not a genvar, and a loop generate's index
// must be one. VerA checks the index against the module's genvar declarations
// at the end of the module and reports E0238, "a loop generate's index is not a
// genvar".
//
// generate_loop.va is the legal neighbour, the same construct with `genvar i;`
// declared before it.
//
//! lrm 6.6.1
//! lrm 6.6.1:1
//! reject-only E0238
//! neighbour generate_loop.va
`include "disciplines.vams"
module ch6_gen_nodecl_index(p);
  inout p; electrical p;
  generate
    for (i = 0; i < 2; i = i + 1) begin end
  endgenerate
endmodule
