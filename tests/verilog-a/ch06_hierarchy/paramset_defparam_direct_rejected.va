// §6.4: "The only restriction on the associated module is that it does not
// contain a defparam statement in or under its hierarchy." Here the associated
// module itself contains the statement. It must be rejected before execution.
// The same ordinary module is legal outside a paramset in the runtime neighbor
// paramset_defparam_hierarchy_legal.va.
// A.1.9: a paramset needs >= 1 paramset_item_declaration (corrected 2026-10-08)
//! lrm 6.4
//! lrm 6.4:1001
//! lrm 6.3.1
//! lrm 6.3.1:2
//! reject-only E0926
//! neighbour paramset_defparam_hierarchy_legal.va
`include "disciplines.vams"
module ps_dp_direct_top(p);
  inout p; electrical p;
  ps_dp_direct_card u(p);
endmodule
paramset ps_dp_direct_card ps_dp_direct_body;
  parameter real unused_item = 0;
  .gain = 2.0;
endparamset
module ps_dp_direct_body(p);
  inout p; electrical p;
  parameter real gain = 1.0;
  ps_dp_direct_leaf child(p);
  defparam child.gain = gain;
endmodule
module ps_dp_direct_leaf(p);
  inout p; electrical p;
  parameter real gain = 1.0;
  analog I(p) <+ gain * V(p);
endmodule
