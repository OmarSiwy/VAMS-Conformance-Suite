// §6.6.2: a generate block is a scope, so a localparam declared in it is
// not visible outside it (IEEE 1364-2005 12.7: "Identifiers ... declared in
// a scope are local to that scope"). The instance below sits outside block
// g1 and reads g1's `ww` by its simple name, which names nothing in the
// module: E0314. paramset_selected_by_generate_localparam.va is the legal
// neighbour, the override written inside the block. (The instance here is
// of a module, not of the overloaded paramset: an unresolvable override
// leaves every member applicable and is reported as E0914 first.)
//! lrm 6.6.2
//! lrm 6.9.2
//! reject-only E0314
//! reject `ww`
//! neighbour paramset_selected_by_generate_localparam.va
`include "disciplines.vams"
paramset ch6_pglo_sel ch6_pglo_leaf;
  parameter real w = 10.0 from [5.0:inf);
  .w = w;
  .gain = 2.0;
endparamset

paramset ch6_pglo_sel ch6_pglo_leaf;
  parameter real w = 1.0 from (-inf:5.0);
  .w = w;
  .gain = 3.0;
endparamset

module ch6_pglo_leaf(a, b);
  inout a, b;
  electrical a, b;
  parameter real gain = 1.0, w = 0.0;
  analog I(a, b) <+ gain * V(a, b);
endmodule

module ch6_pglo_top(p, n);
  inout p, n;
  electrical p, n;
  parameter integer big = 1;
  if (big) begin : g1
    localparam real ww = 10.0;
  end
  ch6_pglo_leaf #(.w(ww)) u1(p, n);
  analog I(p, n) <+ 0.0;
endmodule
