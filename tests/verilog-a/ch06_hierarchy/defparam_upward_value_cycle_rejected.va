// IEEE 1364-2005 12.8.1 b): a defparam whose target "can be resolved within
// the hierarchy elaborated so far must have its target resolved and its value
// applied", and 12.2.1: its value reads "references to parameters ...
// declared in the same module as the defparam statement". AMS 6.3.1
// inherits defparam.
//
// THE DESIGN. w (a dpc_cyc_writer) sets the top's u.g, which the walk reaches
// before w, to its own y. y's value is x, and w's second defparam sets x to y.
// So y's final value is x's, and x's is y's: the value u.g would take has no
// final value at all, however many replacements are made. VerA finds the
// cycle and names it, `w.y` → `w.x` → `w.y`, instead of stopping after a
// count of replacements a legal chain can exceed
// (defparam_upward_value_chain_65.va, the legal neighbour: 65 replacements
// that end). Both defparams read the cycle, so E0907 is reported twice.
//
//! lrm 6.3.1
//! inherited IEEE 1364-2005 12.8.1
//! reject-only E0907
//! reject-only the cycle `w.y` → `w.x` → `w.y`
//! neighbour defparam_upward_value_chain_65.va
`include "disciplines.vams"
module defparam_upward_value_cycle_rejected(p);
  inout p; electrical p;
  dpc_cyc_leaf u(p);
  dpc_cyc_writer w(p);
endmodule
module dpc_cyc_leaf(c);
  inout c; electrical c;
  parameter real g = 0.0;
  analog I(c) <+ g * V(c);
endmodule
module dpc_cyc_writer(c);
  inout c; electrical c;
  parameter real x = 1.0;
  parameter real y = x;
  defparam defparam_upward_value_cycle_rejected.u.g = y;
  defparam w.x = y;
endmodule
