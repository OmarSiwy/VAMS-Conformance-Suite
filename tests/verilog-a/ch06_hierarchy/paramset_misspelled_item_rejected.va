// A.1.9 paramset_item_declaration / paramset_statement, the CLOSED list: a
// parameter or localparam declaration, an aliasparam, an integer/real variable
// declaration, a `.name = expr;` assignment, or an analog_function_statement
// over the paramset's variables. `paramter real rr = 5.0;` is none of these —
// it is `parameter` with a letter missing — and a paramset body used to skip
// any unrecognized item to the next `;` with no diagnostic at all. The typo
// compiled clean and the paramset silently lacked the parameter, so the first
// visible symptom was an E0907 (or a wrong default) at some INSTANCE, files
// away from the missing letter.
//
// The silent skip survives only for what A.1.9 actually admits and VerA
// deliberately drops — a §6.4.3 output-variable assignment (`ft = 3.0 * .gm;`)
// and the §6.4.1 conditional statements around such assignments, both pinned
// green by paramset_output_unsupported.va. Everything else is now E0205 at the
// offending token, which is what this file pins.
//
//! lrm A.1.9
//! lrm 6.4
//! lrm A.1.9:1000
//! reject-only E0205
//! neighbour paramset_output_unsupported.va
`include "disciplines.vams"
module ch6_typo_user(p, n);
  inout p, n; electrical p, n;
  ch6_typo_ps u(p, n);
endmodule

paramset ch6_typo_ps ch6_typo_base;
  paramter real rr = 5.0;
  .k = 2.0;
endparamset

module ch6_typo_base(a, b);
  inout a, b; electrical a, b;
  parameter real k = 9.0;
  analog I(a, b) <+ k * V(a, b);
endmodule
