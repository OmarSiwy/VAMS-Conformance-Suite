// §6.8: "An identifier shall be used to declare only one item within a scope."
// duplicate_declaration_rejected.va pins two VARIABLES; the sentence says ITEM,
// and a parameter and a net are items of the module scope as much as a variable
// is (§6.8 lists what opens a new scope — modules, named blocks, analog
// functions, generate blocks — and a second declaration is not on it).
//
// Two parameters named `k`: the identifier declares two items. Deleting either
// line makes the file legal.
//
//! lrm 6.8
//! lrm 6.8:1
//! reject-only E0362
`include "disciplines.vams"
module ch6_duplicate_parameter(p);
  inout p; electrical p;
  parameter real k = 1.0;
  parameter real k = 2.0;
  analog I(p) <+ k * V(p);
endmodule
