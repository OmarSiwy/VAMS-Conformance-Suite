// §6.6.1: "As a consequence, it is not possible to have two nested loop
// generate constructs that use the same genvar."
//
// Both loops below drive `i`, the module's only genvar. A loop generate binds
// its index as §6.6.1's implicit localparam for the duration of each unrolled
// copy; the inner loop binds `i` afresh, finishes, and releases the binding.
// Back in the outer loop the iteration `i = i + 1` no longer folds — there is
// no `i` binding left to evaluate — so lowering refuses the construct with
// E0419, "genvar loop step is not a constant expression". That is the sentence
// in action: one genvar cannot index both loops, because the inner scheme
// consumes the value the outer scheme needs.
//
// generate_loop.va is the legal neighbour: a single loop generate with its own
// genvar, unrolled and asserted.
//
//! lrm 6.6.1
//! lrm 6.6.1:1002
//! reject-only E0419
//! neighbour generate_loop.va
`include "disciplines.vams"
module ch6_nested_same_genvar(p);
  inout p; electrical p;
  genvar i;
  generate
    for (i = 0; i < 2; i = i + 1)
      for (i = 0; i < 2; i = i + 1)
        begin : inner
          analog I(p) <+ 0.0;
        end
  endgenerate
endmodule
