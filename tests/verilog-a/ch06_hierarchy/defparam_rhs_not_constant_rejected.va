// §6.3.1: "The right-hand side shall be a constant expression involving only
// constant numbers and references to parameters declared in the same module
// as the defparam."
//
// The right-hand side here is `$abstime`, which is neither. §9.10 defines it
// as the current simulation time, a different value at every accepted point,
// so there is no single number the defparam could write into the child's
// parameter — the same reason A.2.4 gives parameter assignments a
// constant_mintypmax_expression at all (§3.4: "The default_value may not be
// changed at runtime"). The defparam carries the expression into the child's
// `g`, which is exactly the value the sentence polices, and `g` is what the
// child's conductance would stamp if the design compiled.
//
// E0363, the constancy diagnostic (ch03_data_types/82_parameter_default_not_
// constant_rejected.va is the same refusal for a parameter written directly),
// is reported against the parameter the defparam binds. The legal neighbour
// defparam_precedence_over_instance_override.va writes numeric literals on
// every right-hand side.
//
//! lrm 6.3.1
//! lrm 6.3.1:5
//! reject-only E0363
//! neighbour defparam_precedence_over_instance_override.va
`include "disciplines.vams"
module defparam_rhs_not_constant_rejected(p, n);
  inout p, n; electrical p, n;
  defparam_rhs_not_constant_rejected_leaf u(p, n);
  defparam u.g = $abstime;
  analog I(p, n) <+ V(p, n);
endmodule

module defparam_rhs_not_constant_rejected_leaf(a, b);
  inout a, b; electrical a, b;
  parameter real g = 1.0;
  analog I(a, b) <+ g * V(a, b);
endmodule
