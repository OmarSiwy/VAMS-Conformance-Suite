// §4.5's third sentence, verbatim:
//
//   "One special analog operator is the limexp() function, which is a version
//    of the exp() function with built-in limits to improve convergence."
//
// read with the clause's first sentence, which is what gives the membership
// teeth:
//
//   "Analog operators are functions which operate on more than just the current
//    value of their arguments. Instead, they maintain their internal state and
//    their output is a function of both the input and the internal state."
//
// THE CLAIM. limexp() is an ANALOG OPERATOR and not one of §4.3's built-in
// mathematical functions. That is a classification, and this file is where the
// classification is observable from source: a parameter default is a constant
// expression (§3.4, A.2.4), a constant expression cannot read anything that
// maintains state, so `limexp(1.0)` cannot be the default of `bad` — while
// `exp(1.0)` can, because A.8.4's `constant_primary` reaches §4.3's functions
// through `constant_analog_built_in_function_call` and reaches no
// `analog_filter_function_call` at all.
//
// The two halves of the contrast are one identifier apart, so the fixture is
// worth exactly what the pair is worth:
//
//   * the accept side is in the tree and does the other half already —
//     ch06_hierarchy/dependent_parameter_transcendental.va writes
//     `parameter real curved = exp(a);` and compiles;
//   * a compiler that files limexp under §4.3 — which the words "a version of
//     the exp() function" invite, and which is a classification error, not a
//     lenient reading — accepts this file, so the `reject` demand below goes
//     unmet and the fixture fails;
//   * a compiler stricter than the LRM, refusing ANY function call in a
//     default, refuses the other file as well; the pair, not this file alone,
//     is what separates the three.
//
// THE DIAGNOSTIC. ch03_data_types/parameter_default_not_constant_rejected.va
// is the same refusal for a different reason — `$abstime` is dynamic (§9.10) —
// and cites the constancy rule itself. Here the default is constant in the
// ordinary sense: `limexp(1.0)` has one value for all time. What disqualifies
// it is that the function is stateful, which is 4.5's sentence and nothing
// else in the LRM. E0363 is the diagnostic and it names the function it read;
// before this file existed, the classification had no source that depended on
// it.
//! lrm 4.5
//! lrm 4.1
//! lrm 4.1:1000
//! reject-only E0363
//! neighbour constant_expression_of_parameters_and_operators.va
`include "disciplines.vams"
module ch04_limexp_not_constant(p, n);
    inout p, n;
    electrical p, n;
    parameter real bad = limexp(1.0);

    analog begin
        I(p, n) <+ V(p, n) * bad;
    end
endmodule
