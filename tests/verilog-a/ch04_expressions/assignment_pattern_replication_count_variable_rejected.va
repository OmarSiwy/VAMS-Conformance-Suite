// A.8.1's replication form of an assignment pattern takes a count that is a
// constant_expression:
//
//     assignment_pattern ::= '{ constant_expression { expression { , expression } } }
//
// The count decides how many ELEMENTS the pattern has, so it must be known at
// elaboration. `k` is an analog `integer` variable, which is not a
// constant_expression (§4.2 / A.8.3 admit literals and parameters, §3.4), even
// though its value here never changes.
//
// assignment_pattern_replication_count_over_parameter.va is the legal
// neighbour, the same count written over a localparam.
//
//! lrm 4.2.14
//! lrm A.8.1
//! lrm 4.2.14:1000
//! lrm A.8.1:1000
//! reject-only E0223
//! neighbour assignment_pattern_replication_count_over_parameter.va
`include "disciplines.vams"
module ch04_pattern_repl_count_variable(p, n);
    inout p, n;
    electrical p, n;
    integer k;
    real values[0:1];

    analog begin
        k = 2;
        values = '{k{0.5}};
        I(p, n) <+ values[1] * V(p, n);
    end
endmodule
