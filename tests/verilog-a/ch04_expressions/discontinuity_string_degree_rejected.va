// §9.17.1 $discontinuity:
//
//   "$discontinuity(i) implies a discontinuity in the i'th derivative of the
//    constitutive equation with respect to either a signal value or time WHERE
//    i MUST BE A NON-NEGATIVE INTEGER."
//
// §3.3 String data type, on what may and may not become one:
//
//   "A string literal can be assigned to a string or an integral type. ...
//    A STRING CANNOT BE ASSIGNED TO AN INTEGRAL TYPE."
//
// The two sentences of §3.3 are deliberately not the same rule, and this
// fixture sits on the second one. A string LITERAL is still a Verilog packed
// bit vector — `$discontinuity("two")` would convert to the integer 0x74776F
// and is a legal, if useless, degree — so the literal spelling is NOT a
// rejection and is not what is written below. A `string`-typed operand is a
// different object with no integral conversion at all, so `deg` cannot be the
// non-negative integer §9.17.1 requires and the call has no meaning.
//
// §3.4.6 makes a string parameter a constant expression, so this passes
// §9.17.1's `constant_expression` requirement and fails only on the type —
// which is the point: the diagnostic has to be about the TYPE, not about
// constness (E0805 already covers a non-constant degree in
// tests/fixtures/ch09_system_tasks/discontinuity_nonconstant_rejected.va).
//
// WHAT USED TO HAPPEN: it compiled, silently, as degree 0 — `Const.asIntExact`
// has the arm `.str => 0`, and `lowerKernelCtl` took that 0 as the announced
// degree, the most severe announcement there is. It is now E0820, the clause's
// own "degree must be nonnegative or -1" verdict, naming the string. (The
// literal spelling now reads as its packed bytes instead of 0.)
//
//! lrm 9.17.1
//! lrm 9.17.1:2
//! lrm 3.3
//! lrm 3.4.6
//! reject-only E0820
`include "disciplines.vams"
module a01_discontinuity_string_degree_rejected(p, n);
  inout p, n;
  electrical p, n;
  parameter string deg = "two";

  analog begin
    $discontinuity(deg);
    I(p, n) <+ V(p, n);
  end
endmodule
