// LRM 4.5.15 names three conditional forms, not one: "Analog operators shall
// not be used inside conditional (if, case, or ?:) statements unless the
// conditional expression controlling the statement consists of terms which can
// not change their value during the course of a simulation."
//
// operator_in_conditional.va covers `if`. This is `case`. The case
// expression is `V(p, n) > 0.0`, a probe comparison, which moves on every
// Newton iteration — so the selected item, and therefore whether `transition`
// is stepped at all, is not fixed for the simulation. The operator's history
// takes a zero on every step its item was not chosen.
//
// operator_under_constant_condition.va is the legal `case` with a
// parameter selector.
//
//! lrm 4.5.15
//! lrm 4.5.15:1
//! reject-only E0514
//! neighbour operator_under_constant_condition.va
`include "disciplines.vams"
module ch04_operator_in_case_rejected(p, n);
    inout p, n;
    electrical p, n;
    real value;

    analog begin
        case (V(p, n) > 0.0)
            1: value = transition(1.0, 0, 1n);
            default: value = 0.0;
        endcase
        I(p, n) <+ value;
    end
endmodule
