// The device tests/fixtures/ch04_expressions/revert_host.zig runs twice, once with a rejected step and
// once without: one §4.5/§5.10/§9.13 construct that keeps history in the
// device per output row, each read off its own node, all fed by V(a).
//
// Corrected 2026-10-08 (construct only, the wants are unchanged): the
// coefficient vectors were VAMS 2.x concatenations, `{...}`. A.8.2's
// analog_filter_function_arg is a parameter, a part of one or a `'{...}`
// assignment pattern (annex G: "Add apostrophe before opening { in list of
// values"), and a concatenation there is E0572
// (reject_4_5_11_concatenation_coefficients.va), so each is now `'{...}`.
`include "disciplines.vams"
module revert_ops(a, o_tr, o_ad, o_sl, o_lp, o_zi, o_lc, o_cr, o_ab, o_tm, o_im, o_rn, o_rc, o_rp, o_ra);
    inout a, o_tr, o_ad, o_sl, o_lp, o_zi, o_lc, o_cr, o_ab, o_tm, o_im, o_rn, o_rc, o_rp, o_ra;
    electrical a, o_tr, o_ad, o_sl, o_lp, o_zi, o_lc, o_cr, o_ab, o_tm, o_im, o_rn, o_rc, o_rp, o_ra;
    parameter integer random_seed = 7;

    real t_cross, t_above;
    integer ticks;

    analog begin
        @(cross(V(a) - 0.5, -1)) t_cross = $abstime;
        @(above(V(a) - 0.5)) t_above = $abstime;
        @(timer(0, 1n)) ticks = ticks + 1;

        I(o_tr) <+ transition(V(a), 0, 1n);
        I(o_ad) <+ absdelay(V(a), 0.5n);
        I(o_sl) <+ slew(V(a), 0.5e9);
        I(o_lp) <+ laplace_nd(V(a), '{1}, '{1, 1n});
        I(o_zi) <+ zi_nd(V(a), '{1}, '{1, -0.5}, 1n);
        I(o_lc) <+ 1e9 * last_crossing(V(a) - 0.5, 0);
        I(o_cr) <+ 1e9 * t_cross;
        I(o_ab) <+ 1e9 * t_above;
        I(o_tm) <+ ticks;
        I(o_im) <+ idtmod(1e9 * V(a), 0, 10);
        I(o_rn) <+ $arandom % 1000;
        // §9.13.1: the rejected negative-voltage attempt is this site's
        // FIRST call, so rollback must restore its first-call flag too.
        if (V(a) < 0) I(o_rc) <+ $arandom(7);
        I(o_rp) <+ $arandom(random_seed);
        I(o_ra) <+ $arandom;
    end
endmodule
