// §4.5.1: "Certain analog operators require arrays or vectors to be passed as
// arguments: Laplace filters, Z-transform filters, noise_table() and
// noise_table_log(). An array can either be passed as an array_identifier
// (e.g. an array parameter or an array variable) or an array assignment
// pattern (see 4.2.14)." §4.5.11 says the same of the Laplace forms: "For
// arguments that require a vector, the vector may be represented as either a
// literal vector or a reference to a vector parameter."
//
// `gain` is a SCALAR real parameter, and it sits in laplace_nd's numerator
// slot. It is neither an array_identifier nor an assignment pattern, so there
// is no coefficient vector for §4.5.11.4's Σ nk s^k to range over — even
// though its value, 2.0, is the one coefficient a writer probably meant.
//
// VerA used to refuse this only in codegen ("codegen refused a construct",
// with no code and no pointer to the argument); E0572 names the slot. The
// one-change neighbour writes `'{gain}` — an assignment pattern of one
// element — and compiles (checked by hand when this fixture was written);
// filter_parameter_arrays.va is the array-parameter spelling.
//
//! lrm 4.5.1
//! lrm 4.5.11.4
//! lrm 4.5.1:1000
//! reject-only E0572
//! neighbour filter_parameter_arrays.va
`include "disciplines.vams"
module ch04_filter_scalar_coefficient(in, n);
    inout in, n;
    electrical in, n;
    parameter real gain = 2.0;
    real y;

    analog begin
        y = laplace_nd(V(in, n), gain, '{1.0, 1n});
        I(in, n) <+ y * 1.0e-3;
    end
endmodule
