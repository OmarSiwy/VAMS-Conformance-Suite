// LRM 4.2.1, both sentences: "The operators shown in Table 4-2 are legal when
// applied to real operands. All other operators are considered illegal when
// used with real operands."
//
// Table 4-2 is a closed list — unary +/-, the arithmetic set + - * / ** and %,
// the relationals > >= < <=, logical equality == !=, the logicals ! && ||, and
// the conditional ?:. Everything outside it is illegal on a real, and that
// "everything" is the bitwise operators (& | ^ ~ , 4.2.9), the shifts (<< >> ,
// 4.2.11) and the reductions (4.2.10). A real is an IEEE double; 4.2.1 gives no
// bit-level meaning to one, and 4.2.1.1's real-to-integer conversion is the
// explicit route a model is meant to take instead.
//
// Two operators from two different tables, so the rule is pinned as the general
// one 4.2.1 states rather than as a quirk of `&`: a bitwise AND and a left
// shift, each with a real left operand. Both are compile-time constants, so the
// diagnosis is static and needs no operating point. Both raise the same code,
// so the single expectation is satisfied by either line alone: the second one
// widens what the fixture covers, it is not a second gate.
//
// (VerA answers E0322, whose catalogue entry cites 4.2.9. 4.2.1 is where the
// rule actually lives; the code is the stable half and is what is matched.)
//
//! lrm 4.2.1
//! lrm 4.2.1:1
//! reject-only E0322
`include "disciplines.vams"
module ch04_real_operand_illegal_operator_rejected(p, n);
    inout p, n;
    electrical p, n;
    integer masked, shifted;

    analog begin
        masked = 1.5 & 3;
        shifted = 1.5 << 2;
        I(p, n) <+ masked + shifted;
    end
endmodule
