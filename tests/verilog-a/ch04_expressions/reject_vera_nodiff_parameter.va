// VerA's `vera_nodiff` attribute (§2.9) with a value the model card decides.
//
// §2.9: `attr_spec ::= attr_name [ = constant_expression ]`. A parameter IS a
// constant expression, but the answer decides which derivatives the emitted
// device computes, before any model card exists, so the value must fold
// without one. E0525 names that.
//! lrm 2.9
//! reject-only E0525
`include "disciplines.vams"
module reject_vera_nodiff_parameter(p, n);
  inout p, n; electrical p, n;
  parameter integer stop = 1;
  real c;
  analog begin
    (* vera_nodiff = stop *) c = V(p, n);
    I(p, n) <+ c / 1e3;
  end
endmodule
