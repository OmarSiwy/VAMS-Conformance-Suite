// LRM 4.5.9, verbatim: "max_pos_slew_rate shall be greater than zero (0) and
// max_neg_slew_rate shall be less than zero (0)."
//
// Two bounds pointing opposite ways, so the two violations are different bugs
// and both are written. The signs are what tell the operator which limit is
// which: 4.5.9 bounds positive transitions by the first rate and negative ones
// by the second, and "If the max_neg_slew_rate is not specified, it defaults to
// the opposite of the max_pos_slew_rate" — a rule that produces a nonsense
// default the moment the first rate is negative.
//
//   slew(x, -1e6, -2e6)   max_pos_slew_rate is negative
//   slew(x,  1e6,  2e6)   max_neg_slew_rate is positive
//
// A guard that only checked that the two rates differ in sign accepts the first
// pair reversed, so each line names one bound and violates only that one. Both
// rates are constants. slew.va is the legal side with (1e6, -2e6).
//
// The two expectations are the LRM's own two argument names, and BOTH must
// appear in the diagnostics. A single `slew rate` fragment would be satisfied
// by whichever of the two violations a half-written guard happened to catch,
// which is exactly the failure mode a two-violation file exists to rule out.
//
//! lrm 4.5.9
//! lrm 4.5.9:1
//! reject-only max_pos_slew_rate
//! reject max_neg_slew_rate
//! reject E0516
//! neighbour slew.va
`include "disciplines.vams"
module ch04_slew_rate_sign_rejected(p, n);
    inout p, n;
    electrical p, n;
    real negative_rise, positive_fall;

    analog begin
        negative_rise = slew(V(p, n), -1e6, -2e6);
        positive_fall = slew(V(p, n), 1e6, 2e6);
        I(p, n) <+ negative_rise + positive_fall;
    end
endmodule
