// LRM 4.5.7: "In all cases td shall be a positive number."
// Zero is the excluded boundary, independently of fixture 127's negative
// value. The legal neighbor is absdelay.va (td=2ns).
//! lrm 4.5.7
//! lrm 4.5.7:1
//! reject-only positive
//! reject E0516
//! neighbour absdelay.va
`include "disciplines.vams"
module audit_absdelay_zero_delay_rejected(p, n);
    inout p, n;
    electrical p, n;
    analog I(p,n) <+ absdelay(V(p,n), 0.0);
endmodule
