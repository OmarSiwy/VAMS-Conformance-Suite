// LRM 4.5.8, verbatim: "td, rise_time, fall_time, and time_tol are optional,
// but if specified shall be non-negative."
//
// Non-negative, so zero is allowed and 4.5.8 says what each zero means — "If
// neither rise_time nor fall_time are specified or are equal to zero (0.0), the
// rise and fall time default to the value defined by `default_transition", "If
// a time_tol value of zero (0.0) is specified, the simulator shall apply a
// suitable value". A NEGATIVE value has no such reading: it would place the end
// of a ramp before its start.
//
// One violation per argument slot, all four in one file, because a guard
// written for the rise/fall pair alone leaves td and time_tol open. Every value
// is a constant. transition.va is the legal side.
//
// Each slot gets its OWN expectation, and every one must appear: a lone
// `non-negative` fragment would be satisfied by whichever single slot a partial
// guard happened to cover, which would defeat the point of writing four.
//
//! lrm 4.5.8
//! lrm 4.5.8:1
//! reject-only non-negative
//! reject td
//! reject rise_time
//! reject fall_time
//! reject time_tol
//! reject E0516
//! neighbour transition.va
`include "disciplines.vams"
module ch04_transition_negative_time_rejected(p, n);
    inout p, n;
    electrical p, n;
    real bad_td, bad_rise, bad_fall, bad_tol;

    analog begin
        bad_td   = transition(V(p, n), -1n, 2n, 3n, 1p);
        bad_rise = transition(V(p, n), 1n, -2n, 3n, 1p);
        bad_fall = transition(V(p, n), 1n, 2n, -3n, 1p);
        bad_tol  = transition(V(p, n), 1n, 2n, 3n, -1p);
        I(p, n) <+ bad_td + bad_rise + bad_fall + bad_tol;
    end
endmodule
