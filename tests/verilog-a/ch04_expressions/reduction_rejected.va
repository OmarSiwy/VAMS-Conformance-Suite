// LRM 4.2.10's prohibition: "The reduction operators can not be
// used inside the analog block and only have meaning when used in the digital
// context."
//
// There is no carve-out and no analog form: `&`, `|`, `~&` and `~|` are banned
// here exactly as `^`, `~^` and `^~` are. The xor spellings are pinned
// separately by reduction_xor_rejected.va and the audit_reduction_xnor_*
// fixtures. This file now isolates |; its formerly combined &, ~& and ~|
// obligations move to reduction_and_rejected.va,
// reduction_nand_rejected.va and reduction_nor_rejected.va.
//
// This replaces a fixture that ASSERTED the four operators' IEEE 1364 values
// inside `analog begin` and called the LRM ban a VerA extension. A conforming
// compiler diagnoses that file and fails it; only VerA passed it. The suite
// tests conformance, so the requirement is written the way the LRM writes it
// rather than accepting an implementation extension as the expected result.
//
//! lrm 4.2.10
//! lrm 4.2.10:1000
//! reject-only E0348
//! neighbour parameter_reduction_and_arithmetic_shift.va
`include "disciplines.vams"
module ch04_reduction_rejected(p, n);
    inout p, n;
    electrical p, n;
    integer bits, value;

    analog begin
        bits = 15;
        value = (|bits);
        I(p, n) <+ value;
    end
endmodule
