// §4.5.11.4: "laplace_nd ( expr , n , d [ , ε ] ) where n is an vector of M
// real numbers containing the coefficients of the numerator and d is a vector
// of N real numbers containing the coefficients of the denominator. The
// transfer function is H(s) = Σ nk s^k / Σ dk s^k".
//
// §4.5.11 grants the null argument to one slot only — "The ZEROS argument may
// be represented as a null argument" — and §4.5.15 closes every other: "It is
// illegal to specify a null argument in the argument list of an analog
// operator, except as specified elsewhere in this document." In laplace_nd the
// denominator is not a zeros list, and an empty d has no reading at all: the
// empty sum is 0, and H(s) = N(s)/0.
//
// Here `d` is written null: `laplace_nd(V(in, n), '{6.0}, )`. With `'{3.0}`
// in that slot the call is laplace_nd_dc_gain.va's first-order form, H(0)
// = 6/3, and compiles (checked by hand when this fixture was written).
//
//! lrm 4.5.11.4
//! lrm 4.5.15
//! lrm 4.5.15:4
//! reject-only E0505
//! neighbour laplace_nd_dc_gain.va
`include "disciplines.vams"
module ch04_laplace_nd_null_denominator(in, n);
    inout in, n;
    electrical in, n;
    real y;

    analog begin
        y = laplace_nd(V(in, n), '{6.0}, );
        I(in, n) <+ y * 1.0e-3;
    end
endmodule
