// LRM 4.7.3: an analog user-defined function "shall not call itself directly or
// indirectly". `first` calls `second` and `second` calls `first`, so neither
// names itself, yet the cycle in the call graph is exactly the indirect case the
// sentence bans. Neither is reached from the analog block, which does not save
// it: the rule constrains the declarations, not the reachable calls.
//
//! lrm 4.7.3
//! lrm 4.7.3:2
//! reject-only E0510
`include "disciplines.vams"
module ch04_function_indirect_recursion(p, n);
    inout p, n;
    electrical p, n;

    analog function real first;
        input x;
        real x;
        first = second(x);
    endfunction

    analog function real second;
        input x;
        real x;
        second = first(x);
    endfunction

    analog I(p, n) <+ V(p, n);
endmodule
