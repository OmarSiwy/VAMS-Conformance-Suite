// LRM 4.5.10, verbatim: "The optional direction indicator shall evaluate to an
// integer expression +1, -1, or 0."
//
// A three-value enumeration written out in full, and 4.5.10 assigns a distinct
// meaning to each one — 0 is "either a rise or falling edge transition", +1 is
// rising, -1 is falling. There is no fourth reading, so +2 does not select
// anything and cannot be clamped to something that does.
//
// Both an out-of-range positive and an out-of-range negative are written: a
// guard spelled `abs(direction) <= 1` is not the same as one spelled
// `direction == 1 || direction == -1 || direction == 0` only if it is written
// on the wrong type, so the two lines cost nothing and separate the cases.
// Both indicators are constants. last_crossing.va is the legal +1 side.
//
//! lrm 4.5.10
//! lrm 4.5.10:1
//! reject-only direction
//! reject last_crossing
//! reject E0516
//! neighbour last_crossing.va
`include "disciplines.vams"
module ch04_last_crossing_direction_rejected(p, n);
    inout p, n;
    electrical p, n;
    real up, down;

    analog begin
        up = last_crossing(V(p, n), 2);
        down = last_crossing(V(p, n), -2);
        I(p, n) <+ up + down;
    end
endmodule
