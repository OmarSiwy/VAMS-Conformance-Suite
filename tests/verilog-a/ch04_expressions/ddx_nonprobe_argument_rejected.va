// LRM 4.5.6: ddx()'s second argument names the unknown to differentiate with
// respect to — "unknown_quantity is the branch probe (voltage or current probe)
// with respect to which the derivative of the expression needs to be computed"
// — and "The second argument shall be the potential of a scalar net or port or
// the flow through a branch".
//
// A real variable is none of those. It is not in the solver's unknown vector at
// all, so there is nothing to hold the other unknowns fixed against. This is
// the crude violation that a syntactic check catches; 131 is the same rule
// violated by something that IS an access function call.
//
//! lrm 4.5.6
//! lrm 4.5.6:1
//! reject-only E0504
`include "disciplines.vams"
module ch04_ddx_nonprobe_argument_rejected(p, n);
    inout p, n;
    electrical p, n;
    real y, slope;

    analog begin
        y = 3.0;
        slope = ddx(V(p, n) * 2.0, y);
        I(p, n) <+ slope;
    end
endmodule
