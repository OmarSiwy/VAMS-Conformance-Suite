// §4.5.3 Table 4-17: "ddt(expr, abstol) — Same as above, except absolute
// tolerance is specified explicitly." §4.5.14's Table 4-20 sorts the
// operator's arguments: for ddt, the "Constant expression arguments" column
// holds `abstol` and the "Dynamic expression arguments" column holds `expr` —
// "The constant expressions remain static throughout an analysis." A.8.3
// agrees: `abstol_expression ::= constant_expression | nature_identifier`.
//
// Here the tolerance is V(b), a node potential, which moves with every Newton
// iteration; `expr` is a legal dynamic operand, so the second argument is the
// one defect. With `1e-3` in that slot the same call is ddt_output_abstol.va's
// explicit-abstol form, which compiles and publishes 1e-3 as the output's
// tolerance; idt_abstol_dynamic_rejected.va is the idt counterpart.
//
//! lrm 4.5.3
//! lrm 4.5.14
//! reject-only E0515
//! neighbour ddt_output_abstol.va
`include "disciplines.vams"
module ch04_ddt_abstol_dynamic(a, b);
    inout a, b;
    electrical a, b;

    analog I(a, b) <+ ddt(V(a), V(b));
endmodule
