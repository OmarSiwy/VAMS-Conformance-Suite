// §4.1: "Some statement constructs require an expression to be a constant
// expression. The operands of a constant expression consists of constant
// numbers and parameter names, but they can use any of the operators defined
// in Table 4-1, Table 4-14, and Table 4-15."
//
// A parameter's default is one of those constructs (A.2.4
// `constant_mintypmax_expression`). `gain`'s default reads V(p, n) — an access
// function (§4.4), which is neither a constant number nor a parameter name, and
// whose value moves with every Newton iteration. Every OPERATOR in it (`*`,
// `+`) is from Table 4-1, so the operand is the one thing wrong.
//
// The legal neighbour, one change away, is 190_constant_expression_of_
// parameters_and_operators.va's shape: replace `V(p, n)` with the parameter
// `base` and the file compiles (checked by hand when this fixture was
// written).
//
//! lrm 4.1
//! lrm 4.1:1000
//! reject E0363
`include "disciplines.vams"
module ch04_constant_expression_reads_a_probe(p, n);
    inout p, n;
    electrical p, n;
    parameter real base = 2.0;
    parameter real gain = 2.0 * V(p, n) + 1.0;

    analog I(p, n) <+ gain * base * V(p, n);
endmodule
