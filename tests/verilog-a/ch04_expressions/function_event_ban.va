// LRM 4.7.1 bullet list: an analog user-defined function "shall not use
// contribution statements or event control statements" — this is the event
// half. (Not 5.2.1 — that clause is the `analog initial` block.)
//! lrm 4.7.1
//! lrm 4.7.1:3
//! reject-only E0702
`include "disciplines.vams"
module ch4_fn_event(p); inout p; electrical p; analog function real sampled; input x; real x; begin @(cross(x,1)) sampled=x; end endfunction analog I(p)<+sampled(V(p)); endmodule
