// LRM 4.5.7: "In all cases td shall be a positive number."
// Isolate the optional-maxdelay form: fixture 127 also has a two-argument
// violation, whose error alone could satisfy its rejection expectation.
// A positive maxdelay cannot make negative td legal.
//! lrm 4.5.7
//! lrm 4.5.7:1
//! reject-only positive
//! reject E0516
`include "disciplines.vams"
module audit_absdelay_three_arg_negative_rejected(p, n);
    inout p, n;
    electrical p, n;
    analog I(p,n) <+ absdelay(V(p,n), -2n, 5n);
endmodule
