// §4.5.15, second bullet, verbatim and entire: "Analog operators shall not be
// used inside event triggered statements."
//
// This is a DIFFERENT bullet from the one 89/90/91 pin — those are the third,
// "Analog operators are not allowed in the repeat, while and non-genvar for
// looping statements", and §5.9's looping-statement list. Neither says anything
// about an event body, and this bullet says nothing about loops. There is no
// analysis_or_constant carve-out on either: §4.5.15's first bullet grants one
// to `if`/`case`/`?:` alone (operator_under_constant_condition.va is that
// carve-out being exercised), and an event body is not a conditional statement.
//
// This fixture used to assert the opposite — that the illegal form COMPILES.
//
// Its legal neighbour is rc_88_operator_outside_event.va: this module with the
// ddt moved out of the event body. (Reconciler, 2026-10-08: the neighbour was
// 119, the if/case carve-out, which has no event body and so could not show
// that this refusal is about the operator INSIDE one.)
//! lrm 4.5.15
//! lrm 4.5.15:2
//! lrm 4.5.15:3
//! reject-only E0514
//! neighbour rc_88_operator_outside_event.va
// §5.10.3.1: `cross()` "maintains its internal state and has the same
// restrictions as analog operators" — an event body runs only when the event
// fires, so `ddt` inside one misses every other step. Rejected as E0514.
`include "disciplines.vams"
module ch4_op_event(p); inout p; electrical p; real x; analog begin @(cross(V(p),1)) x=ddt(V(p)); I(p)<+x; end endmodule
