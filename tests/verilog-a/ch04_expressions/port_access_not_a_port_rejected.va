// LRM 4.4 restricts the port-access form `<...>` to a PORT: the argument list of
// a signal access function is "a branch identifier, or a list of one or two nets
// or port expressions", and 5.4.3 says what the angle brackets mean — I(<p>) is
// the flow into port p from outside the module.
//
// `internal` is declared electrical but is not in the module's port list, so it
// has no outside and no boundary for a flow to cross. The rule is a shape rule
// on the argument, not on the discipline: `internal` would be a perfectly legal
// argument to the ordinary form I(internal, n).
//
// port_access.va is the legal side.
//
//! lrm 4.4
//! lrm 4.4:1003
//! lrm A.8.9
//! lrm A.8.9:1000
//! reject-only E0508
//! neighbour port_access.va
`include "disciplines.vams"
module ch04_port_access_not_a_port_rejected(p, n);
    inout p, n;
    electrical p, n;
    electrical internal;

    analog I(p, n) <+ I(<internal>);
endmodule
