// LRM 4.4, Table 4-16: `V(n1,n1)  Error` and `I(n1,n1)  Error`, and the prose
// under the table is normative -- "If two net expressions are given as
// arguments to a flow access function, they shall not evaluate to the same
// signal." Annex G Table G.1 records why the spelling exists at all: `I(a,a)`
// was the OVI Verilog-A v1.0 form of the port flow, replaced in v2.0 by
// `I(<a>)`. A branch from p to p is not a branch with zero potential; it is
// not a branch.
//
// The replacement spelling is covered by port_access.va.
//
//! lrm 4.4
//! lrm 4.4:2
//! lrm G.1
//! lrm 4.4:4
//! reject-only E0315
//! neighbour port_access.va
`include "disciplines.vams"
module ch4_same_flow(p);
  inout p; electrical p;
  analog begin
    I(p,p) <+ 1m;
  end
endmodule
