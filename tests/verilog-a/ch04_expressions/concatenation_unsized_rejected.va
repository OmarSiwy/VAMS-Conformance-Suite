// LRM 4.2.13, verbatim: "Unsized constant numbers shall not be allowed in
// concatenations. This is because the size of each operand in the concatenation
// is needed to calculate the complete size of the concatenation."
//
// The clause gives its own reason, and the reason is what makes this a hard
// error rather than a default: 4.2.13 opens by defining a concatenation as "the
// joining together of bits", so the result width is the sum of the operand
// widths. An unsized `1` has no width to add, and picking one for it — 1 bit,
// or 3.2.1's 32-bit integer — would silently change the value of every operand
// to its left. `{1, 4'b0101}` is 5 with a 1-bit guess and 0x15 with a 32-bit
// one; the LRM refuses to choose.
//
// The unsized operand is written first so it cannot be mistaken for a width
// inferred from context. concatenation.va is the legal, all-sized case, and
// asserts the 165 that this rule protects.
//
//! lrm 4.2.13
//! lrm 4.2.13:2
//! reject-only E0216
//! neighbour concatenation.va
`include "disciplines.vams"
module ch04_concatenation_unsized_rejected(p, n);
    inout p, n;
    electrical p, n;
    integer packed_value;

    analog begin
        packed_value = {1, 4'b0101};
        I(p, n) <+ packed_value;
    end
endmodule
