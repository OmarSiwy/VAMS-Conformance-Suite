// §4.5.12.4: "zi_nd ( expr , n , d , T [ , τ [ , t0 ] ] ) where n is an vector
// of M real numbers containing the coefficients of the numerator and d is a
// vector of N real numbers containing the coefficients of the denominator.
// The transfer function is H(z) = Σ nk z^-k / Σ dk z^-k".
//
// §4.5.12 lets exactly one argument be null — "The zeros argument may be
// represented as a null argument" — and §4.5.15 refuses the rest: "It is
// illegal to specify a null argument in the argument list of an analog
// operator, except as specified elsewhere in this document." The denominator
// of the nd form is a coefficient vector, not a zeros list, and the empty
// sum is 0: H(z) = N(z)/0 is no filter.
//
// Here `d` is written null. With `'{1.0, 0.5}` in its place the call is
// zi_dc_gains.va's zi_nd, which settles to 2, and the file compiles
// (checked by hand when this fixture was written).
//
//! lrm 4.5.12.4
//! lrm 4.5.15
//! lrm 4.5.15:4
//! reject-only E0505
//! neighbour zi_dc_gains.va
`include "disciplines.vams"
module ch04_zi_nd_null_denominator(in, n);
    inout in, n;
    electrical in, n;
    real y;

    analog begin
        y = zi_nd(V(in, n), '{1.0, 2.0}, , 1u);
        I(in, n) <+ y * 1.0e-3;
    end
endmodule
