// LRM 4.4, verbatim: "The argument expression list for signal access functions
// shall be a branch identifier, or a list of one or two nets or port
// expressions."
//
// One or two. A potential is defined between two points and a flow through one
// branch, so a third net has no place to go: V(p, n, q) does not name a
// quantity the solver has an unknown for.
//
// signal_access.va is the legal one- and two-net side.
//
//! lrm 4.4
//! lrm 4.4:1
//! reject-only E0207
//! neighbour signal_access.va
`include "disciplines.vams"
module ch04_access_three_nets_rejected(p, n, q);
    inout p, n, q;
    electrical p, n, q;

    analog I(p, n) <+ V(p, n, q);
endmodule
