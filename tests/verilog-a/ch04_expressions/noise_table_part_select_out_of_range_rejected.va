// §4.6.4.3 takes the noise table as "an array parameter", and A.8.2 spells a
// part select of one as `parameter_identifier [ msb_constant_expression :
// lsb_constant_expression ]`. §3.2.2 makes the declared range the array's
// elements, so a select reaching past it names elements that do not exist:
// tbl is [0:5] and tbl[2:7] needs tbl[6] and tbl[7]. VerA refuses it with
// E0310 rather than reading undefined knots. Legal neighbour:
// noise_table_parameter_part_select.va (tbl[2:7] of a [0:9] array).
//! lrm 4.6.4.3
//! reject-only E0310
//! neighbour noise_table_parameter_part_select.va
`include "disciplines.vams"
module noise_table_part_select_out_of_range_rejected(p, n);
    inout p, n;
    electrical p, n;
    parameter real tbl[0:5] = '{1.0, 1e-18, 1e3, 1e-21, 1e6, 1e-24};
    analog I(p, n) <+ V(p, n) / 1000.0 + noise_table(tbl[2:7], "tbl");
endmodule
