// Host-only stimulus for language_semantics_observations.py.
// External source rises at 1 ns and falls at 12 ns. With td=2 ns, corners are
// 3/7 ns (rise) and 14/22 ns (fall). No fixture time grid supplies corners.
`include "disciplines.vams"
module transition_resolution(in, omitted, zero, explicit_tol);
    inout in, omitted, zero, explicit_tol;
    electrical in, omitted, zero, explicit_tol;
    analog begin
        V(omitted) <+ transition(V(in), 2n, 4n, 8n);
        V(zero) <+ transition(V(in), 2n, 4n, 8n, 0.0);
        V(explicit_tol) <+ transition(V(in), 2n, 4n, 8n, 1p);
    end
endmodule
