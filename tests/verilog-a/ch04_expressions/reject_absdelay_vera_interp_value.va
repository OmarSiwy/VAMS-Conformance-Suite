// VerA's `vera_interp` attribute (§2.9) on `absdelay` (§4.5.7) names an
// interpolation order: 1 (the clause's linear) or 2 (quadratic). 3 names
// neither, and E0524 says so rather than picking one.
//! lrm 2.9
//! reject-only E0524
`include "disciplines.vams"
module reject_absdelay_vera_interp_value(p, n);
  inout p, n; electrical p, n;
  real y;
  analog begin
    y = absdelay (* vera_interp = 3 *) (V(p, n), 1n);
    I(p, n) <+ y;
  end
endmodule
