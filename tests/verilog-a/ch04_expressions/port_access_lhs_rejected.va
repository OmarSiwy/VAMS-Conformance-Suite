// LRM 4.4, verbatim: "If the signal access function is being used on the left
// side of a branch assignment or contribution statement, it assigns a value to
// the signal. A port access function can not be used on the left side of a
// branch assignment or contribution statement."
//
// That second sentence is the whole difference between the two kinds of access
// function 4.4 opens by naming. A branch access `I(p)` is bidirectional: read
// it in an expression, contribute to it on the left of `<+`. A port access
// `I(<p>)` is read-only, because it measures what the world outside the module
// pushes through port p — 3.12.1's port branch — and a module does not get to
// assign that. 5.4.3 says the same thing from the other side.
//
// So `I(<p>) <+ 1.0;` is the violation, and nothing else in the module is:
// port_access.va already reads `I(<p>)` on the RIGHT of a contribution and
// asserts its value. This file is the half of Table 4-16's last row that the
// value assertion cannot reach.
//
//! lrm 4.4
//! lrm 4.4:1001
//! lrm 5.4.3
//! lrm 5.4.3:1
//! reject-only E0407
//! neighbour port_access.va
`include "disciplines.vams"
module ch04_port_access_lhs_rejected(p);
    inout p;
    electrical p;

    analog begin
        I(<p>) <+ 1.0;
    end
endmodule
