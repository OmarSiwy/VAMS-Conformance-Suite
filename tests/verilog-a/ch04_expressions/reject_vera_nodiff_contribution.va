// VerA's `vera_nodiff` attribute (§2.9) over a contribution statement.
//
// The attribute stops the derivative of the ASSIGNMENTS inside it. On a
// contribution it would stop the whole branch: the residual keeps its value and
// Newton gets no Jacobian for it, so it could never move the branch. E0526.
//! lrm 2.9
//! reject-only E0526
`include "disciplines.vams"
module reject_vera_nodiff_contribution(p, n);
  inout p, n; electrical p, n;
  analog begin
    (* vera_nodiff *) I(p, n) <+ V(p, n) / 1e3;
  end
endmodule
