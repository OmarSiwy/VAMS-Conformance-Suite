// LRM 4.3.2, the sentence immediately above Table 4-15: "Input values outside
// of the valid range for the operator shall report an error."
//
// Table 4-15's Domain column is what "valid range" means, and it is explicit:
//
//   asin(x)   -1 <= x <= 1
//   acos(x)   -1 <= x <= 1
//   acosh(x)  x >= 1
//   atanh(x)  -1 < x < 1        (open — atanh(1) is a pole, not a value)
//
// One call per bound, each just outside it, so a compiler that clamped instead
// of diagnosing, or that checked only the closed forms, is caught:
//
//   asin(2.0)    above the upper bound of a closed interval
//   acos(-2.0)   below the lower bound of the same interval
//   acosh(0.5)   below a one-sided bound
//   atanh(1.0)   AT the bound of an OPEN interval, which is the case a
//                `-1 <= x <= 1` check would wrongly admit
//
// Every argument is a constant, so the error is decidable at compile time and
// the fixture needs no operating point. Table 4-14's own Domain column is the
// same rule for the standard functions and is pinned by
// standard_math_domain_rejected.va; the legal, in-domain side of Table 4-15
// is transcendental_math.va, which is built to stay inside every bound here.
//
// Not pinned: tan(x)'s "x != n(pi/2), n is odd". That bound is not reachable in
// a double — no representable argument is exactly an odd multiple of pi/2 — so
// requiring a diagnostic for it would be requiring one that can never fire.
//
//! lrm 4.3.2
//! lrm 4.3.2:2
//! reject-only E0605
//! reject E0606
//! reject E0607
//! neighbour transcendental_math.va
`include "disciplines.vams"
module ch04_transcendental_domain_rejected(p, n);
    inout p, n;
    electrical p, n;
    real above_one, below_minus_one, under_acosh, at_atanh_pole;

    analog begin
        above_one = asin(2.0);
        below_minus_one = acos(-2.0);
        under_acosh = acosh(0.5);
        at_atanh_pole = atanh(1.0);
        I(p, n) <+ above_one + below_minus_one + under_acosh + at_atanh_pole;
    end
endmodule
