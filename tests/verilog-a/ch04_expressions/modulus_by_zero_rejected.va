// LRM 4.2.4, verbatim and without qualification: "It shall be an error to pass
// zero (0) as the second argument to the modulus operator."
//
// The sentence does not distinguish integer from real. 4.2.1's Table 4-2 lists
// `%` among the operators legal on real operands, and 4.2.4 immediately goes on
// to define the real case — "a % b = ((a/b) < 0) ? (a - ceil(a/b)*b) :
// (a - floor(a/b)*b)" — which divides by b just as the integer case does. So
// this fixture isolates the integer spelling. The formerly combined real
// spelling moves to real_modulus_zero_rejected.va so either diagnostic
// cannot mask absence of the other. No real-division rule is inferred from
// this clause's silence about division by zero.
//
// Constant zeros, so the violation is decidable without running anything:
// modulo.va covers the legal `% 2.0` case with digits.
//
//! lrm 4.2.4
//! lrm 4.2.4:1
//! reject-only E0601
//! neighbour modulo.va
`include "disciplines.vams"
module ch04_modulus_by_zero_rejected(p, n);
    inout p, n;
    electrical p, n;
    integer whole;

    analog begin
        whole = 11 % 0;
        I(p, n) <+ whole;
    end
endmodule
