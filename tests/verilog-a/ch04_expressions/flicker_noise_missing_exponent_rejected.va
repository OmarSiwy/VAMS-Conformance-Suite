// §4.6.4.2 / Syntax 4-4: `flicker_noise` takes TWO analog expressions. The
// exponent is not optional.
//
// Syntax 4-4, verbatim, in the LRM's own bracket notation where `[ ]` marks
// what may be omitted:
//
//     analog_small_signal_function_call ::=
//         ...
//       | white_noise ( analog_expression [ , string ] )
//       | flicker_noise ( analog_expression , analog_expression [ , string ] )
//
// The name is bracketed in both; the exponent is not. §4.6.4.2 states the same
// form in prose — "flicker_noise ( pwr , exp [ , name ] )" — and the exponent
// is load-bearing: "generates pink noise with a power of pwr at 1Hz which
// varies in proportion to 1/f exp". A one-argument call has no spectrum.
//
// WHY THIS IS A REFUSAL AND NOT A DEFAULT. There is no default in the clause,
// and inventing one is not conservative: `flicker_noise(kf)` read as exp = 1
// silently gives a 1/f source, while a model that meant `1/f^af` and lost the
// argument to a typo gets no diagnostic. §4.6.4.1's `white_noise(pwr)` is the
// one-argument member of the family and is how a flat spectrum is spelled, so
// nothing legal is lost by refusing this.
//
// VerA used to accept it — lowering seeded the exponent slot with `.f_one` —
// and the generated device exported a `flicker` row with `.ef = 1`. It is now
// E0522, "flicker_noise requires an exponent". Grammar, not folklore: the
// LRM's brackets say so.
//
// THE `//! reject` PATTERN. `//! reject flicker_noise` would have had no teeth
// (`failureContains` also matches the generated Zig, which carries the name in
// this module's own), and the later `DiagnosticsReported` / rule-phrase
// placeholders held only until the rule had a code. It has one now.
//
//! lrm 4.6.4.2
//! lrm A.8.2
//! lrm 4.6.4.2:1000
//! lrm A.8.2:1000
//! reject-only E0522
//! neighbour psd_white_flicker_export.va
`include "disciplines.vams"
module a06_flicker_noise_missing_exponent_rejected(p, n);
    inout p, n;
    electrical p, n;

    analog I(p, n) <+ V(p, n) / 1000.0 + flicker_noise(1e-20);
endmodule
