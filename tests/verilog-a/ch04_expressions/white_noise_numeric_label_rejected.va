// §4.6.4.1: "white_noise ( pwr [ , name ] ) which generates white noise with a
// power of pwr. ... The optional name argument acts as a label for the noise
// source used when the simulator outputs the individual contribution of each
// noise source to the total output noise." Syntax 4-4 types the slot:
//
//     white_noise ( analog_expression [ , string ] )
//
// Here the second argument is the integer 5. It is not a string, so it is no
// label; and white_noise has exactly one power, so it cannot be read as a
// second PSD operand either. The power `4 * 1.380649e-23 * 300 / 1k` is the
// clause's own thermal-noise shape at 300 K and 1 kohm. With `"thermal"` in
// the second slot — the clause's example — the file compiles (checked by hand
// when this fixture was written); noise_source_name.va runs that form.
//
//! lrm 4.6.4.1
//! lrm 4.6.4.1:1000
//! reject-only E0573
//! neighbour noise_source_name.va
`include "disciplines.vams"
module ch04_white_noise_numeric_label(a, b);
    inout a, b;
    electrical a, b;

    analog I(a, b) <+ V(a, b) / 1k + white_noise(4 * 1.380649e-23 * 300 / 1k, 5);
endmodule
