// §4.5.12: "τ specifies the transition time, is optional, and shall be
// nonnegative." A τ of -1n names no transition. The refusal is E0540 with the
// clause's sentence; the legal neighbour, τ = 1n and τ = 0 on the same filter,
// runs in zi_transition_time_and_first_transition.va.
//
// Corrected 2026-10-08 (construct only, the wants are unchanged): the
// coefficient vectors were VAMS 2.x concatenations, `{...}`. A.8.2's
// analog_filter_function_arg is a parameter, a part of one or a `'{...}`
// assignment pattern (annex G: "Add apostrophe before opening { in list of
// values"), and a concatenation there is E0572
// (reject_4_5_11_concatenation_coefficients.va), so each is now `'{...}`.
//
//! lrm 4.5.12
//! lrm 4.5.12:2
//! reject-only E0540
//! reject shall be nonnegative
//! neighbour zi_transition_time_and_first_transition.va
`include "disciplines.vams"
module zi_negative_transition_time_rejected(in, n);
  inout in, n; electrical in, n;
  real y;
  analog begin
    y = zi_nd(V(in, n), '{1.0}, '{1.0}, 2n, -1n);
    I(in, n) <+ y * 1.0e-3;
  end
endmodule
