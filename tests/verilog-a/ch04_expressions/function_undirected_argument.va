// LRM 4.7.1 requires that "all formal arguments shall have an associated
// direction specification that shall be either input, output, or inout".
//
// `undirected` declares `real x;` and nothing else, so `x` is a local variable
// and the function has ZERO formals. That is the only observable form the
// violation can take: a declaration with no direction is not a formal that is
// missing something, it is not a formal at all, and no compiler can tell the
// two intentions apart from the source.
//
// A DECLARATION of zero formals is 4.7.1's other bullet — "shall have at least
// one formal argument declared" — so that is the rule this module breaks and
// E0224 is the diagnostic, raised where the function is declared and before any
// call is looked at.
//
// This file used to pin E0511 "wrong number of arguments" instead, on the
// reasoning that the only OBSERVABLE consequence was the arity mismatch at the
// call site (one actual against an empty formal list). That reasoning was a
// statement about what VerA checked, not about the LRM: the day the declaration
// rule is checked, it fires first and the call is never reached. It is checked
// now, so the pin moved to the rule rather than to its downstream symptom.
//
// function_no_arguments.va is the same E0224 reached the other way, from a
// function that declares no argument and is called with none. The two files
// still differ in what a reader learns — this one records that a block item
// declaration with no direction is not an under-specified formal, it is a local
// variable — but they no longer differ in verdict, and 4.7.1 is the reason: the
// clause gives a compiler no way to tell the two intentions apart.
//
//! lrm 4.7.1
//! lrm 4.7.1:3
//! reject-only E0224
`include "disciplines.vams"
module ch04_function_undirected_argument(p, n);
    inout p, n;
    electrical p, n;

    analog function real undirected;
        real x;
        undirected = x;
    endfunction

    analog I(p, n) <+ undirected(V(p, n));
endmodule
