// LRM 4.6.4.3, verbatim: "Each frequency value must be unique."
//
// It is the one ordering rule of the clause that sorting cannot repair. The
// sentence before it makes ORDER the simulator's problem — "the simulator shall
// internally sort the pairs into ascending frequency if required" — so a
// descending table is legal and `noise_table_topology.va` is the fixture
// that compiles one. A repeated frequency is different: it names two powers at
// one point, the interpolation the clause defines has a zero-width segment to
// divide by, and no sort resolves which of the two the spectrum should read.
//
//! lrm 4.6.4.3
//! lrm 4.6.4.3:6
//! reject-only E0519
//! reject appears twice
//! neighbour noise_table_topology.va
`include "disciplines.vams"
module ch04_noise_table_duplicate_frequency_rejected(p, n);
    inout p, n;
    electrical p, n;

    analog I(p, n) <+ noise_table('{1.0, 1.0e-18, 1.0, 1.0e-24});
endmodule
