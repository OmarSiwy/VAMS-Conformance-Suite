// LRM 4.5.15, fourth bullet: analog operators "can only be used inside an
// analog block; they can not be used inside an initial or always block, or
// inside a user-defined function". 4.7.1's bullet list says it from the other
// side: an analog user-defined function "shall not use analog filter
// functions". Not 5.2.1 — that clause is the `analog initial` block.
//! lrm 4.5.15
//! lrm 4.5.15:1001
//! lrm 4.7.1
//! lrm 4.7.1:3
//! reject-only E0422
//! neighbour ddt.va
`include "disciplines.vams"
module ch4_op_function(p); inout p; electrical p; analog function real stateful; input x; real x; stateful=ddt(x); endfunction analog I(p)<+stateful(V(p)); endmodule
