// LRM 4.7.3: an analog user-defined function "shall not call itself directly or
// indirectly, i.e., recursive functions are not permitted". `recurse` names
// itself in its own body, which is the direct case, so the module is illegal
// however the ?: guard is written -- the ban is on the call graph, not on
// whether a base case exists.
//
// function_indirect_recursion.va is the two-function cycle.
//
//! lrm 4.7.3
//! lrm 4.7.3:2
//! reject-only E0510
`include "disciplines.vams"
module ch04_function_direct_recursion(p, n);
    inout p, n;
    electrical p, n;

    analog function real recurse;
        input x;
        real x;
        recurse = (x > 0.0) ? recurse(x - 1.0) : 0.0;
    endfunction

    analog I(p, n) <+ V(p, n);
endmodule
