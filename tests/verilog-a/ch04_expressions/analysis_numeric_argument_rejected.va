// §4.6.1: "The analysis() function takes one or more string arguments and
// returns one (1) if any argument matches the current analysis type." A.8.2
// writes the quotation marks into the production itself:
//
//     analysis_function_call ::= analysis ( " analysis_identifier "
//                                           { , " analysis_identifier " } )
//
// `analysis(1)` passes a number, which Table 4-21 has no row for and which is
// not a string at all. The rest of the file is the clause's own nodeset/ic
// pattern. With `analysis("ic")` the file compiles (checked by hand when this
// fixture was written); analysis.va runs that form and asserts it.
//
// VerA used to accept the call and hand codegen a Zig expression that did not
// compile — an engine error with no source position. E0574 names the argument.
//
//! lrm 4.6.1
//! lrm 4.6.1:1001
//! reject-only E0574
//! neighbour analysis.va
`include "disciplines.vams"
module ch04_analysis_numeric_argument(p, n);
    inout p, n;
    electrical p, n;
    integer is_ic;

    analog begin
        is_ic = analysis(1);
        I(p, n) <+ is_ic * V(p, n) * 1.0e-3;
    end
endmodule
