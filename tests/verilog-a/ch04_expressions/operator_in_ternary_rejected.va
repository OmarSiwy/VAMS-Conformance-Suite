// LRM 4.5.15's third conditional form: "Analog operators shall not be used
// inside conditional (if, case, or ?:) statements unless the conditional
// expression controlling the statement consists of terms which can not change
// their value during the course of a simulation."
//
// `?:` is the one that is easy to miss, because it is an operator inside an
// expression rather than a statement — a checker that walks statement kinds
// looking for `if` and `case` never sees it. 4.2.3 makes it worse: `?:` is
// listed with `&&` and `||` as short-circuiting, so the unselected arm is not
// evaluated, which is exactly how an analog operator loses its history.
//
// The condition here is a probe comparison, so it changes across the solve.
// operator_under_constant_condition.va is the legal parameter-guarded `?:`.
//
//! lrm 4.5.15
//! lrm 4.5.15:1
//! reject-only E0514
//! neighbour operator_under_constant_condition.va
`include "disciplines.vams"
module ch04_operator_in_ternary_rejected(p, n);
    inout p, n;
    electrical p, n;
    real value;

    analog begin
        value = (V(p, n) > 0.0) ? transition(1.0, 0, 1n) : 0.0;
        I(p, n) <+ value;
    end
endmodule
