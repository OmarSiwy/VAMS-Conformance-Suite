// LRM 4.2.11, verbatim: "There are two types of shift operators: the logical
// shift operators, << and >>, and the arithmetic shift operators, <<< and >>>.
// The arithmetic shift operators can not be used in an analog block."
//
// The clause is 4.2.11 Shift operators, not 4.2.9 — 4.2.9 is Bitwise
// operators, and every operator in that clause IS legal here (56..62 run them).
//
// The expression is the single banned token and nothing else, so the
// diagnostic can only have come from `>>>`. arithmetic_shift_left_rejected.va
// is the `<<<` half; 60 and 61 are the legal `<<` and `>>`.
//
// The FILE NAME is stale — this is a `>>>` reject, not a bitwise-or-shift value
// test. It keeps the name older notes cite (tests/fixtures/ch04_expressions/COVERAGE.md at
// 8b1514d4); the two lines above are what the file actually pins.
//
//! lrm 4.2.11
//! lrm 4.2.11:1000
//! reject-only E0324
//! neighbour shift_right.va
`include "disciplines.vams"
module ch04_bitwise_shift(p, n);
    inout p, n;
    electrical p, n;
    integer a, value;

    analog begin
        a = 5;
        value = a >>> 1;
        I(p, n) <+ value;
    end
endmodule
