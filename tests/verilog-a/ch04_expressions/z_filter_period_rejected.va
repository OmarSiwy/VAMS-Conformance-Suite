// LRM 4.5.12, verbatim: "All Z-transform filters share three common arguments:
// T, tau, and t0. T specifies the period of the filter, is mandatory, and shall
// be positive."
//
// T is the sampling period, and 4.5.12 opens by saying what it means: "A filter
// with unity transfer function acts like a simple sample-and-hold which samples
// every T seconds". A period of zero samples infinitely often and a negative
// one samples backwards; neither names a schedule the filter can run on, and
// z^-1 — one T of delay — is undefined for both.
//
// Both violations are written because "positive" excludes two different things
// — a guard spelled `T != 0` admits the negative one and a guard spelled
// `T >= 0` admits zero. Both raise the same message, so the single expectation
// is satisfied by either line on its own: the second line widens what the
// fixture covers, it is not a second gate. Both are constants.
// z_transform_filters.va is the legal side with T = 1u.
//
// VerA enforces this in codegen rather than as a numbered diagnostic, so the
// expectation is the message fragment and not an E-code.
//
//! lrm 4.5.12
//! lrm 4.5.12:2
//! reject-only filter shall be positive
//! neighbour z_transform_filters.va
`include "disciplines.vams"
module ch04_z_filter_period_rejected(p, n);
    inout p, n;
    electrical p, n;
    real zero_period, negative_period;

    analog begin
        zero_period = zi_zd(V(p, n), '{0.0, 0.0}, '{1.0, -0.5}, 0.0);
        negative_period = zi_zd(V(p, n), '{0.0, 0.0}, '{1.0, -0.5}, -1u);
        I(p, n) <+ zero_period + negative_period;
    end
endmodule
