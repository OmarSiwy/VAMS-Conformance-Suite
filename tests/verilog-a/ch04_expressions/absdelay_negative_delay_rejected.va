// LRM 4.5.7, verbatim: "input is delayed by the amount td. In all cases td
// shall be a positive number."
//
// "In all cases" is the LRM closing the door on the optional-maxdelay form as
// well as the two-argument one, so both spellings are written below. A negative
// td asks the operator for Output(t) = Input(max(t - td, 0)) with t - td in the
// FUTURE, which the transport-delay history buffer cannot supply — a delay line
// only holds the past.
//
// Both delays are constants, so the check is static. absdelay.va is the
// legal side with td = 2n.
//
// `td` on its own is a two-character substring — "stdout" contains it — so the
// LRM's own word for the bound is required alongside it.
//
//! lrm 4.5.7
//! lrm 4.5.7:1
//! reject-only td
//! reject positive
//! reject E0516
//! neighbour absdelay.va
`include "disciplines.vams"
module ch04_absdelay_negative_delay_rejected(p, n);
    inout p, n;
    electrical p, n;
    real two_arg, three_arg;

    analog begin
        two_arg = absdelay(V(p, n), -2n);
        three_arg = absdelay(V(p, n), -2n, 5n);
        I(p, n) <+ two_arg + three_arg;
    end
endmodule
