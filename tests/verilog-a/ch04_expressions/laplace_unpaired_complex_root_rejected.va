// LRM 4.5.11.1, verbatim: "If a root is real, the imaginary part shall be
// specified as zero (0). If a root is complex, its conjugate shall also be
// present." 4.5.11.2, .3 and 4.5.12.1 repeat the sentence for zeros, poles and
// Z-filter roots respectively.
//
// The rule is what keeps the filter REAL. H(s) is built as a product of
// (1 - s/r) factors; a complex r contributes a complex factor, and only its
// conjugate partner can cancel the imaginary part back out. With '{-1, 1} as
// the only pole — a single root at -1+j and no -1-j — the transfer function has
// complex coefficients, so a real input produces a complex output and there is
// no real number for the operator to return.
//
// The pole vector here is one pair short of laplace_filters.va's legal
// '{-1,-1,-1,1}, which IS the conjugate pair -1-j and -1+j. The roots are
// literal constants, so the pairing is decidable at compile time.
//
// VerA enforces this in codegen rather than as a numbered diagnostic, so the
// expectation is the message fragment and not an E-code. The fragment is
// specific enough that it cannot match the generated device text by accident,
// which a bare "conjugate" would.
//
//! lrm 4.5.11.1
//! lrm 4.5.11.1:2
//! reject-only no conjugate partner
//! neighbour laplace_filters.va
`include "disciplines.vams"
module ch04_laplace_unpaired_complex_root_rejected(p, n);
    inout p, n;
    electrical p, n;
    real y;

    analog begin
        y = laplace_zp(V(p, n), '{-1.0, 0.0}, '{-1.0, 1.0});
        I(p, n) <+ y;
    end
endmodule
