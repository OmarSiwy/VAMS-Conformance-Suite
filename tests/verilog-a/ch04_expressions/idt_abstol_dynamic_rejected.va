// §4.5.4 Table 4-18: "idt(expr,ic,assert,abstol) — Same as above, except the
// absolute tolerance used to control the error in the numerical integration
// process is specified explicitly with abstol." §4.5.14's Table 4-20 sorts the
// operator's arguments: for idt, the "Constant expression arguments" column
// holds `abstol` and the "Dynamic expression arguments" column holds `expr,
// ic, assert` — "The constant expressions remain static throughout an
// analysis." A.8.3 agrees: `abstol_expression ::= constant_expression |
// nature_identifier`.
//
// Here the tolerance is V(b), a node potential, which moves with every Newton
// iteration. expr, ic and assert are all legal dynamic operands; the fourth
// argument is the one defect. With `1u` in that slot the same call is
// idt.va's explicit-abstol form and compiles (checked by hand when this
// fixture was written); ddt_idt_nature_tolerance.va is the nature spelling.
//
//! lrm 4.5.4
//! lrm 4.5.14
//! reject-only E0515
//! neighbour ddt_idt_nature_tolerance.va
//! neighbour idt.va
`include "disciplines.vams"
module ch04_idt_abstol_dynamic(a, b);
    inout a, b;
    electrical a, b;

    analog V(b) <+ idt(V(a), 0.0, 0, V(b));
endmodule
