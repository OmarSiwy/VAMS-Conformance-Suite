// LRM 4.7.2.2, verbatim: "The return statement shall override any value
// assigned to the function name. When the return statement is used, the
// function shall specify an expression with the return of the correct type for
// the function."
//
// "shall specify an expression" — a bare `return;` specifies none. The sentence
// is not redundant with 4.7.2.1's default-value rule: 4.7.2.1 covers a function
// that never returns explicitly at all, and says it yields the identifier
// variable's initial value. A `return` with nothing after it is a different
// thing, an explicit return of nothing, and 4.7.2.2 makes it an error rather
// than a third spelling of the default.
//
// The function is declared `real`, so the "correct type" half of the sentence
// has an answer to compare against and there is nothing here for it to be.
//
// function_return.va is the legal side, including the override rule.
//
//! lrm 4.7.2.2
//! lrm 4.7.2.2:2
//! reject-only return
//! reject expression
//! reject E0227
//! neighbour function_return.va
`include "disciplines.vams"
module ch04_function_bare_return_rejected(p, n);
    inout p, n;
    electrical p, n;

    analog function real early;
        input x;
        real x;
        begin
            return;
        end
    endfunction

    analog I(p, n) <+ early(1.0);
endmodule
