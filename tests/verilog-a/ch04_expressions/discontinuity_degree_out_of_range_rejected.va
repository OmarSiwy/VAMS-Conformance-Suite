// §9.17.1 $discontinuity: the degree "must be a non-negative integer", and
// §3.2 says how large an integer this language has:
//
//   "An integer declaration declares one or more variables of type integer.
//    THESE VARIABLES CAN HOLD VALUES RANGING FROM -2^31 TO 2^31-1."
//
// 1e300 is a perfectly ordinary real constant and §4.2.1.1's conversion rule
// ("rounding the real number to the nearest integer") names no integer this
// language can represent. So the call is an error, and the error is the
// deliverable: a compiler has to SAY so.
//
// WHAT HAPPENS TODAY: the compiler crashes. `Const.asInt`
// (`lib/ir/lower.zig:800`) is
//
//   .real => |r| @intFromFloat(@round(r)),
//
// with no range test, and Zig's `@intFromFloat` on a value outside the target's
// range is illegal behaviour — caught in a safety build, undefined in a release
// one. Reproduced verbatim:
//
//   thread ... panic: integer part of floating point value out of bounds
//   lib/ir/lower.zig:804:26: in asInt
//               .real => |r| @intFromFloat(@round(r)),
//   lib/ir/lower.zig:6769:29: in lowerKernelCtl
//               degree = c.asInt();
//   exit status 134
//
// THE SAME LINE is the non-finite case: `$discontinuity(1.0/0.0)` folds to an
// infinity and panics identically, at the same two frames. One guard in
// `Const.asInt` covers both, and covers 92_nonfinite_array_subscript_rejected.va
// as well — that fixture reaches the same line through a subscript instead of a
// system task, which is why the fix belongs in the shared converter and not at
// either call site.
//
// The expected diagnostic is a rejection naming the task; E0820 ("$discontinuity
// degree must be nonnegative or -1") is the closest existing code and printing
// a range complaint under it would be a conforming answer. What is NOT
// conforming is aborting the compiler, which reports nothing and takes the rest
// of the file's diagnostics with it.
//
//! lrm 9.17.1
//! lrm 3.2
//! lrm 4.2.1.1
//! lrm 9.17.1:2
//! reject-only $discontinuity
`include "disciplines.vams"
module a01_discontinuity_degree_out_of_range_rejected(p, n);
  inout p, n;
  electrical p, n;

  analog begin
    $discontinuity(1e300);
    I(p, n) <+ V(p, n);
  end
endmodule
