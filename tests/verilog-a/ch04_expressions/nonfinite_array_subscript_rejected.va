// §3.2 Integer and real data types, on array bounds:
//
//   "Arrays of integers can be declared using a range which defines the upper
//    and lower indices of the array. BOTH INDICES SHALL BE CONSTANT EXPRESSIONS
//    AND SHALL EVALUATE TO A POSITIVE INTEGER, A NEGATIVE INTEGER, OR ZERO (0)."
//
// A reference's subscript is held to the same arithmetic: §4.2.1.1 converts a
// real to an integer "by rounding the real number to the nearest integer", and
// an infinity has no nearest integer. `a[1.0/0.0]` therefore names no element
// of `a[0:3]` and is an error — the same verdict
// tests/fixtures/ch04_expressions has for a constant subscript outside the
// declared range (E0310).
//
// WHAT HAPPENS TODAY: the compiler crashes, in the same shared converter
// 91_discontinuity_degree_out_of_range_rejected.va reaches through a system
// task. `Const.asInt` (`lib/ir/lower.zig:800`) is
//
//   .real => |r| @intFromFloat(@round(r)),
//
// with no finiteness or range test, and `lowerIndex` calls it on every folded
// subscript. Reproduced verbatim:
//
//   thread ... panic: integer part of floating point value out of bounds
//   lib/ir/lower.zig:804:26: in asInt
//   exit status 134
//
// `a[1e300]` panics identically — a finite constant that simply has no i64. Two
// call sites, one bug; the guard belongs in `Const.asInt`, where both the
// subscript path and the §9.17.1 degree path already go.
//
// The expected diagnostic is E0310, `lib/ir/lower.zig:4137`, "index {d} is
// outside dimension {d} of `{s}[{d}:{d}]`" — the verdict this compiler already
// reaches for a constant subscript outside the declared range, which is exactly
// what a non-finite subscript is once `asInt` refuses to invent an integer for
// it. What is not acceptable is an abort, which produces no diagnostic at all
// and loses every other error in the file.
//
// Corrected after review: this file used to say `//! reject index`. That is a
// substring, so it is not the bare-`//! reject` hole — but `index` also matches
// E0311's title "array index is not a constant expression", which is a
// WRONG-REASON diagnostic and one this very row provokes on purpose in fixture
// 04. A guard that bailed out of `Const.asInt` by declaring the subscript
// non-constant would have satisfied the old directive while getting the clause
// backwards: `1.0/0.0` IS a constant expression; it just is not an integer.
// Pinning the code closes that. If the project prefers to mint a new code for
// "this constant has no integer value", move this line to that code — do not
// widen it back to a substring that E0311 answers.
//
//! lrm 3.2
//! lrm 3.2:1
//! lrm 3.2:2
//! lrm 4.2.1.1
//! reject-only E0310
`include "disciplines.vams"
module a01_nonfinite_array_subscript_rejected(p, n);
  inout p, n;
  electrical p, n;
  real a[0:3];

  analog begin
    a[0] = 0.0; a[1] = 1.0; a[2] = 2.0; a[3] = 3.0;
    I(p, n) <+ a[1.0 / 0.0];
  end
endmodule
