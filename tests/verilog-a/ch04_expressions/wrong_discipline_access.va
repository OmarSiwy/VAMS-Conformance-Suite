// LRM 4.4: "The name of the access function for a signal is taken from the
// discipline of the net, port, or branch where the signal or port is
// associated", and "The access function name shall match the discipline
// declaration for the nets, ports, or branch given in the argument expression
// list."
//
// `p` is `ch4_custom_d`, whose potential nature `ch4_custom_p` declares
// `access = CustomV` (3.6.2.1: "The access function defined in the nature bound
// to potential ... is called the potential access function"). So `CustomV` is
// the only discipline-derived spelling for p's potential; `V` is electrical's
// access function and does not match p's discipline, so `V(p) <+ 0.0;` is the
// violation and this module shall not compile.
//
// One rule, one file: what the LEGAL spelling then returns is 4.4's other half
// and lives in custom_discipline_access.va. Before the split this file had
// no `reject` at all and its only assertion was on the legal spelling — a want
// a conforming compiler never reaches, because it diagnoses line 22 first.
//
//! lrm 4.4
//! lrm 4.4:5
//! reject-only E0501
//! neighbour custom_discipline_access.va
`include "disciplines.vams"
nature ch4_custom_p; units="V"; access=CustomV; abstol=1u; endnature
nature ch4_custom_f; units="A"; access=CustomI; abstol=1p; endnature
discipline ch4_custom_d; potential ch4_custom_p; flow ch4_custom_f; enddiscipline
module ch4_wrong_discipline(p);
  inout p;
  ch4_custom_d p;
  analog begin
    V(p) <+ 0.0;
  end
endmodule
