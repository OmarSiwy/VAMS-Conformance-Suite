// §4.6.4 declares a noise generator ON A BRANCH, and §1.3.1.1 makes ground the
// reference node — not an unknown of the system, so it has no row and no
// column. A contribution from ground to ground therefore names no branch at
// all: nothing for a current to flow through, nothing for a voltage to be
// measured across.
//
// For the large-signal residual that is harmless and VerA drops it in silence,
// because KCL at the reference node is the one equation the solver does not
// write. A noise generator is different because it is EXPORTED: the device's
// §4.6.4 table names the (row, col) a host stamps each generator into, and this
// generator has neither. Dropping it would delete a declared noise source
// without telling anyone — a PSD the host never learns to ask for — and
// inventing a row would put noise on a branch the model never wrote.
//
// The resistor below is what keeps this fixture about the noise source: the
// module has a real branch and a real solve, and the only thing wrong with it
// is where the generator was put.
//
//! lrm 4.6.4
//! lrm 1.3.1.1
//! reject-only E0520
//! reject ground-ground
`include "disciplines.vams"
module ch04_noise_generator_without_branch_rejected(p);
    inout p;
    electrical p;
    ground gnd_node;
    electrical gnd_node;

    analog begin
        I(p) <+ V(p) * 1.0e-3;
        I(gnd_node, gnd_node) <+ white_noise(1.0e-20, "nowhere");
    end
endmodule
