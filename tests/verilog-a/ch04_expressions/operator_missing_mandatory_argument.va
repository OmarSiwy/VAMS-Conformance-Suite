// A.8.2 gives every analog operator its mandatory arguments — everything left
// of the grammar's first `[`:
//
//     ddt      ( analog_expression [ , abstol_expression ] )
//     absdelay ( analog_expression , analog_expression [ , constant_expression ] )
//
// so `ddt()` has no production at all, and `absdelay(x)` is missing the `td`
// A.8.2 puts before its first bracket — §4.5.7 defines the operator BY that
// delay ("absdelay() implements the transport delay"), so there is no default
// to fall back to and §4.5.14's "the general form" lists td unbracketed too.
//
// Both used to compile: the per-slot null check only judged slots that were
// WRITTEN (`ddt(,1.0)` — operator_null_argument.va), so a list that
// stopped early skipped it entirely. `ddt()` lowered as d/dt of nothing — a
// silent zero — and `absdelay(V(p,n))` as a zero-delay pass-through, i.e. the
// operator's whole meaning dropped without a word.
//
//! lrm A.8.2
//! lrm 4.5.14
//! lrm A.8.2:1000
//! reject-only E0505
`include "disciplines.vams"
module ch04_operator_missing_mandatory_argument(p, n);
    inout p, n;
    electrical p, n;
    real x, y;

    analog begin
        x = ddt();
        y = absdelay(V(p, n));
        I(p, n) <+ x + y;
    end
endmodule
