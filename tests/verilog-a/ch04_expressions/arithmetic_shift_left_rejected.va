// LRM 4.2.11 bans BOTH arithmetic shift operators from an analog block: "the
// arithmetic shift operators, <<< and >>>. The arithmetic shift operators can
// not be used in an analog block."
//
// bitwise_shift.va pins `>>>`. This is `<<<`, so a compiler that only
// filtered the right-shift spelling is caught. The two are separate tokens in
// the grammar, and a hand-written lexer that special-cases one can easily miss
// the other.
//
//! lrm 4.2.11
//! lrm 4.2.11:1000
//! reject-only E0324
//! neighbour shift_left.va
`include "disciplines.vams"
module ch04_arithmetic_shift_left_rejected(p, n);
    inout p, n;
    electrical p, n;
    integer a, value;

    analog begin
        a = 5;
        value = a <<< 1;
        I(p, n) <+ value;
    end
endmodule
