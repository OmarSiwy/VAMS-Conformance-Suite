// AMS4.5.11.2 printedp81: a complex zero must have its conjugate present.
// The lone zero -1+j lacks -1-j; denominator1 is otherwise valid. This tests
// the zero vector of zero/denominator form independently of fixture133's
// unpaired pole in zero/pole form. The same-form legal neighbor is
// laplace_zd_conjugate_zeros.va; fixture23's pair is instead a pole pair.
//! lrm 4.5.11.2
//! lrm 4.5.11.2:2
//! reject-only no conjugate partner
//! neighbour laplace_zd_conjugate_zeros.va
`include "disciplines.vams"
module audit_laplace_zd_unpaired_zero_rejected(p,n);
    inout p,n;
    electrical p,n;
    analog I(p,n) <+ laplace_zd(V(p,n), '{-1.0,1.0}, '{1.0});
endmodule
