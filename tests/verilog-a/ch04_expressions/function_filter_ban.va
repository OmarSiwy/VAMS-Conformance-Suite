// LRM 4.7.1 bullet list: an analog user-defined function "shall not use analog
// filter functions". (Not 5.2.1 — that clause is the `analog initial` block.)
//! lrm 4.7.1
//! lrm 4.7.1:3
//! reject-only E0422
`include "disciplines.vams"
module ch4_fn_filter(p); inout p; electrical p; analog function real filt; input x; real x; filt=laplace_nd(x,'{1.0},'{1.0,1.0}); endfunction analog I(p)<+filt(V(p)); endmodule
