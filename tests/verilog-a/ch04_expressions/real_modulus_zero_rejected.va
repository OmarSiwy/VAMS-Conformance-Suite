// AMS 4.2.4 requires an error for zero as the modulus divisor; Table 4-2
// admits real operands, and the real formula in 4.2.4 also divides by b.
// Isolate the real path formerly combined with the integer error in
// modulus_by_zero_rejected.va. A diagnostic on an integer expression
// elsewhere must not let a missing real check pass.
// Legal neighbor: modulus_sign_combinations.va uses divisor 2.0.
//! lrm 4.2.4
//! lrm 4.2.4:1
//! reject-only E0601
//! neighbour modulus_sign_combinations.va
`include "disciplines.vams"
module audit_real_modulus_zero_rejected(p, n);
    inout p, n;
    electrical p, n;
    real fraction;
    analog begin
        fraction = 5.5 % 0.0;
        I(p,n) <+ fraction;
    end
endmodule
