// §5.8.1 "If any of the conditionally-executed statements contains an analog
// operator, the conditional expression shall be a analysis_or_constant_
// expression." `V(p, n) > 0.0` is a probe: it moves on every Newton iteration.
//
// This fixture used to assert the opposite — that the illegal form COMPILES.
//! lrm 4.5.15
//! lrm 4.5.15:1
//! reject-only E0514
// §5.8.1: the conditional expression governing a statement that contains an
// analog operator shall be an analysis_or_constant_expression. `V(p,n) > 0.0`
// is neither, so `transition` here is fed 0 on every step its arm was off and
// its history is wrong from then on. Rejected as E0514.
`include "disciplines.vams"
module ch04_operator_in_conditional(p, n);
    inout p, n;
    electrical p, n;

    analog begin
        if (V(p, n) > 0.0)
            I(p, n) <+ transition(1.0, 0.0, 1n);
        else
            I(p, n) <+ transition(0.0, 0.0, 1n);
    end
endmodule
