// LRM 4.5.15, fifth bullet, verbatim: "It is illegal to specify a null argument
// in the argument list of an analog operator, except as specified elsewhere in
// this document."
//
// The two places the "except" points at are 4.5.11 and 4.5.12, which carry the
// identical sentence "The zeros argument may be represented as a null argument.
// The null argument is characterized by two adjacent commas (,,) in the
// argument list." Both are about the ZEROS argument of a filter, and nothing
// else in the LRM opens the carve-out any wider.
//
// `ddt` takes the expression to differentiate as its FIRST argument and has no
// default for it: there is nothing to differentiate. Table 4-20 lists no
// optional first argument for any analog operator, so `ddt(, 1.0)` is not the
// abbreviation of anything and 4.5.15's default applies.
//
// filter_null_zeros_argument.va is the legal side — the 4.5.11/4.5.12
// carve-out, where the omitted argument does have a defined meaning.
//
// E0502 is the per-operator form of E0505 and names `ddt` in its message, so it
// pins WHICH argument slot had no default rather than only that one did not.
//
//! lrm 4.5.15
//! lrm 4.5.15:4
//! lrm 4.5.11
//! lrm 4.5.12
//! reject-only E0502
//! neighbour filter_null_zeros_argument.va
`include "disciplines.vams"
module ch04_operator_null_argument(p, n);
    inout p, n;
    electrical p, n;

    analog I(p, n) <+ ddt(, 1.0);
endmodule
