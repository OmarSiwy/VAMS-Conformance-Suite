// LRM 4.2.13, verbatim: "expressions containing replications shall not appear
// on the left-hand side of an assignment".
//
// A replication builds a VALUE by repeating bits; it does not name storage, and
// there is no rule that says which of the repeated copies an assignment would
// have written to. lib/diag_code.zig E0317 already quotes this exact sentence.
//
// replication.va is the legal right-hand-side use.
//
//! lrm 4.2.13
//! lrm 4.2.13:3
//! reject-only E0317
//! neighbour replication.va
`include "disciplines.vams"
module ch04_replication_lhs_rejected(p, n);
    inout p, n;
    electrical p, n;
    integer a, b;

    analog begin
        b = 1;
        {2{a}} = b;
        I(p, n) <+ a;
    end
endmodule
