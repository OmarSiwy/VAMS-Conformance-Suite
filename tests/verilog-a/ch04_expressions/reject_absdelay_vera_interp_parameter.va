// VerA's `vera_interp` attribute (§2.9) with a value the model card decides.
//
// §2.9: `attr_spec ::= attr_name [ = constant_expression ]`. A parameter IS a
// constant expression, but the value picks which kernel VerA emits for the
// `absdelay` site, before any model card exists, so it must fold without
// one. E0524 names that.
//! lrm 2.9
//! reject-only E0524
`include "disciplines.vams"
module reject_absdelay_vera_interp_parameter(p, n);
  inout p, n; electrical p, n;
  parameter integer order = 2;
  real y;
  analog begin
    (* vera_interp = order *) y = absdelay(V(p, n), 1n);
    I(p, n) <+ y;
  end
endmodule
