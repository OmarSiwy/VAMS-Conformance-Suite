// LRM 4.7.1, verbatim: an analog user-defined function "shall only reference
// locally-defined variables, variables passed as arguments, locally-defined
// parameters and module-level parameters". A genvar is none of the four: §3.5
// makes it an integer-valued identifier of the generate construct, not a
// parameter, and it is declared at module level, not in the function.
//
// The call below sits inside the genvar loop, which is the case that matters:
// outside the loop `k` has no value at all and any compiler refuses it. Inside
// the loop a compiler that inlines the body in the caller's scope sees `k`
// bound to 0 and then 1 and accepts the file, which is a function body reading
// its CALLER'S genvar.
//
// The observable consequence is the scope-lookup failure 103_function_
// nonlocal_variable.va pins for a module variable: E0314, naming `k`.
//
//! lrm 4.7.1
//! lrm 3.5
//! lrm 4.7.1:3
//! reject-only E0314
//! reject `k`
`include "disciplines.vams"
module ch04_function_reads_genvar_rejected(p, n);
    inout p, n;
    electrical p, n;
    genvar k;

    analog function real f;
        input x;
        real x;
        f = x + k;
    endfunction

    analog begin
        for (k = 0; k < 2; k = k + 1)
            I(p, n) <+ f(V(p, n));
    end
endmodule
