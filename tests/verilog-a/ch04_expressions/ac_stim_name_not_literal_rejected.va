// §4.6.3 / A.8.2: the analysis name of `ac_stim` is a STRING LITERAL, not an
// expression.
//
//     analog_small_signal_function_call ::=
//           ac_stim ( [ " analysis_identifier " [ , analog_expression
//                                               [ , analog_expression ] ] ] )
//
// The quotation marks are part of the production. Both numeric arguments are
// `analog_expression` — `ac_stim_dynamic_magnitude.va` is the fixture that
// requires them to be — and the name is deliberately not one: §4.6.3 makes the
// source's activation a property of the ANALYSIS ("the name of a small-signal
// analysis is implementation dependent"), which a simulator resolves before it
// begins solving, so there is nothing for a solve-time string to mean.
//
// A string PARAMETER is the interesting near-miss, and it is what this fixture
// passes: §4.6.4.3 explicitly allows one for a noise table's file name ("The
// file name argument shall be constant and will be either a string literal or a
// string parameter"), so the two clauses differ, and a compiler that treats all
// string arguments alike gets this one wrong.
//
// The rule broken is A.8.2's production. VerA used to accept the module and
// emit a device that did not compile ("unused function parameter" in the
// `eval` signature), which the harness reported as an ENGINE bug rather than a
// model error. It is now E0521, "ac_stim analysis name is not a string
// literal", at the argument.
//
// THE `//! reject` PATTERN. `//! reject ac_stim` would have had no teeth:
// `failureContains` matches the generated Zig too, which carries `ac_stim` in
// this module's own name. The drafts' placeholder `DiagnosticsReported` held
// only while no code existed; the code is named now.
//
//! lrm 4.6.3
//! lrm A.8.2
//! lrm A.8.2:1000
//! reject-only E0521
//! neighbour ac_stim_dynamic_magnitude.va
`include "disciplines.vams"
module a06_ac_stim_name_not_literal_rejected(p, n);
    inout p, n;
    electrical p, n;
    parameter string nm = "ac";

    analog I(p, n) <+ V(p, n) / 1000.0 + ac_stim(nm, 2.0, 0.0);
endmodule
