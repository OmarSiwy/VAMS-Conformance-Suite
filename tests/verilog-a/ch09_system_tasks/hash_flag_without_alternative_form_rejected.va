// §9.4.3: "The format specifications in Table 9-23 are used for real numbers
// and have the full formatting capabilities available in the C language."
// The grant names Table 9-23. C11 7.21.6.1p6's '#' (the "alternative form")
// is therefore VerA's to render on %e/%f/%g (s01_14 to s01_16), and on
// nothing else:
//
//   %h %o %d   Table 9-22's rows are Verilog's, sized by IEEE 1364-2005
//              §17.1.1.3 (`%h` of a 32-bit integer is eight hex digits), not
//              by C; no clause says whether '#' adds C's "0x" or "0" to an
//              auto-sized field.
//   %r         §2.6.2 engineering notation, which C does not have.
//   %m %l      Table 9-22's names, no number at all.
//
// So the flag is refused, E0825, rather than guessed
// (`specification/Vague_Decisions.md` §6, AMS 9.4.3).
//
// The last line is #41's false pairing error: lowering read the '#' of
// `%#m` and `%#l` as the conversion letter, counted both as consuming, and
// reported E0810 ("3 consuming format specifiers but 1 arguments") for a
// format whose only consuming conversion is the %d. `reject-only` makes an
// E0810 here a failure.
//
// The legal neighbour is real_hash_flag_g_keeps_trailing_zeros.va:
// '#' on %g compiles and prints C's alternative form.
//
// A reject, so there is nothing to run and no `want` to write.
//
//! lrm 9.4.3
//! reject-only E0825
//! neighbour real_hash_flag_g_keeps_trailing_zeros.va
`include "disciplines.vams"
module s01_hash_flag_without_alternative_form_rejected(p, n);
  inout p, n; electrical p, n;
  integer k;
  analog begin
    k = 255;
    $strobe("%#h", k);
    $strobe("%#x", k);
    $strobe("%#o", 8);
    $strobe("%#d", 1);
    $strobe("%#r", 1.5);
    $strobe("%#m %#l %d", 1);
    I(p,n) <+ V(p,n);
  end
endmodule
