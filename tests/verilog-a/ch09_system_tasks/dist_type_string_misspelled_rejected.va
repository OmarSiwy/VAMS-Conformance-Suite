// §9.13.2's grammar half of the type_string rule. 133 pins the SCOPE half —
// a type_string outside a paramset — and 175 the legal use; what is left is
// the spelling, which Syntax 9-9 closes to exactly two strings:
//
//   type_string ::= "global" | "instance"
//
// There is no third production and no "anything else is ignored" sentence, so
// a call inside a paramset whose trailing string is neither is an error, not a
// silently-dropped argument. "local" is the plausible misspelling — it reads
// like "instance" and a compiler that merely tests "is the last argument a
// string?" accepts it.
//
// The rejection must ALSO not be 132/133's scope error: the call is inside a
// paramset, where a type_string is where it belongs, and the complaint is
// about its value — which is why the pinned substring quotes the grammar
// rather than the scope sentence.
//
// A.1.9: a paramset needs >= 1 paramset_item_declaration (corrected 2026-10-08)
//! lrm 9.13.2
//! reject-only E0816
//! reject shall be "global" or "instance"
`include "disciplines.vams"
module ch09_ts_bad_user(p, n);
  inout p, n; electrical p, n;
  ch09_ts_bad_bin u(p, n);
endmodule

paramset ch09_ts_bad_bin ch09_ts_bad_base;
  parameter real unused_item = 0;
  .k = $rdist_normal(7, 0.0, 1.0, "local");
endparamset

module ch09_ts_bad_base(a, b);
  inout a, b; electrical a, b;
  parameter real k = 9.0;
  analog I(a, b) <+ k * V(a, b);
endmodule
