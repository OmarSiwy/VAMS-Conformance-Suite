// The specified Erlang product underflows. A nonfinite reference result
// cannot be represented by the integer wrapper; diagnose before conversion.
// A.1.9: a paramset needs >= 1 paramset_item_declaration (corrected 2026-10-08)
//! lrm 9.13.3
//! reject-only E0816
//! reject cannot be represented
`include "disciplines.vams"
module ch09_rng_paramset_nonfinite_integer_rejected(p, n);
  inout p, n; electrical p, n;
  sampled u(p, n);
endmodule
paramset sampled base;
  parameter real unused_item = 0;
  .r = $dist_erlang(7, 4097, 3, "global");
endparamset
module base(p, n);
  inout p, n; electrical p, n;
  parameter integer r = 0;
  analog I(p,n) <+ V(p,n) + r;
endmodule
