// §9.5.3: the format "can be a string variable whose content is interpreted
// as the format string", and §9.4.3 bounds no field width. A device has no
// allocator, so VerA sizes each formatting row when the model compiles
// (specification/Vague_Decisions.md §7): a format known only while the
// device runs gets its own text plus each operand's widest rendering, never
// less than 4096 bytes. A width spelled in that run-time text can ask for
// more than any row the compiler could size, and §9.5.3 gives no truncation
// rule, so the run fails loudly with E1011 and a nonzero status, never a cut
// string.
//
// HAND DERIVATION. At V(p) = 2.0 the format is "%9000d", picked by the bias
// while the device runs. Its row is max(4096, 6 + 512) = 4096 bytes, and the
// field needs 9000: E1011. The legal neighbour picks "%4000d" the same way,
// which fits.
//
//! lrm 9.5.3
//! reject-run E1011
//! neighbour sformat_runtime_width_within_its_row.va
//! bias V(p) = 2.0
`include "disciplines.vams"
module sformat_runtime_width_past_its_row_rejected(p, n);
  inout p, n; electrical p, n;
  string f, s;
  analog begin
    f = (V(p, n) > 1.0) ? "%9000d" : "%10d";
    $sformat(s, f, 1);
    I(p,n) <+ V(p,n) * (s == "");
  end
endmodule
