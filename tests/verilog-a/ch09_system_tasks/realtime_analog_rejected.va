// §9.2 Table 9-7 (the §9.10 functions): `$realtime  Yes  No` — digital context only. This one row
// the LRM states twice, and the second time in prose, with a note none of the
// other three rows gets:
//
//   "NOTE — In previous versions of the Verilog-AMS LRM, $realtime was
//    supported in the analog context and it had an additional argument. This
//    version of the LRM deprecates using $realtime in the analog context."
//
// The NOTE is context, not the rule. "Deprecates" is not "shall not", and a
// conforming compiler that merely warned about it would satisfy the note — so
// this reject does not rest on it. It rests on Table 9-7's analog-context "No"
// cell, which is a flat prohibition, and that table sits under §9.2 "Categories
// of System Tasks and Functions", cited below alongside §9.10. §9.10 itself is
// a PERMISSION ("a new function is added called $abstime that can be used from
// the analog and digital contexts") and forbids nothing; abstime.va is the
// positive for that half.
//
// What the note adds is why $realtime gets its own file rather than sharing 149
// with $time/$stime: $realtime in an analog block used to be legal, model source
// in the wild still does it, and the LRM went out of its way to withdraw it.
//
// A reject, so there is nothing to run and no `want` to write.
//
//! lrm 9.2
//! lrm 9.10
//! lrm 9.2:1000
//! reject-only analog context
//! reject E0806
//! neighbour abstime.va
`include "disciplines.vams"
module ch09_realtime_analog_rejected(p, n);
  inout p, n; electrical p, n;
  real t;
  analog begin
    t = $realtime;
    I(p,n) <+ V(p,n) + t;
  end
endmodule
