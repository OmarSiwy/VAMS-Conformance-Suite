// §9.4.3, stated twice in the chapter — once in §9.4.1 and once here:
//
//   "For each % character (except %m, %% and %l) that appears in a string, a
//    corresponding expression argument shall be supplied after the string."
//
// The parenthesis is what makes this a checkable rule rather than a formatting
// preference: three specifiers consume no argument and every other one consumes
// exactly one, so the count is determined by the format string alone and a
// compiler can check it without running anything.
//
// `$display("%d %d", 1)` has two consuming specifiers and one argument. The
// legal neighbour is display_formats.va, whose first line carries six
// consuming specifiers and six arguments and whose second carries four and
// four, plus the %% and %m that the parenthesis excuses and that add nothing
// to either count.
//
// ON THE REMEDY. §9.5.3 blesses a softer response for $sformat — "if not enough
// arguments are supplied for the format specifiers or too many are supplied,
// then the application shall issue a warning and continue execution" — but that
// latitude is scoped to $sformat's own argument processing, and the same
// sentence goes on to permit the hard one: "the application, if possible, can
// statically determine a mismatch in format specifiers and number of arguments
// and issue a compile time error message." §9.4.3's rule for $display is a bare
// "shall be supplied" with no such allowance, the mismatch here IS statically
// determinable (a literal format string, a literal argument list), and this
// suite has exactly one way to express "the program is illegal". So: reject.
//
// The reject substring is `format specifier`, from the rule, not the bare word
// `argument` it used to be — which any arity diagnostic in the chapter matches,
// E0802's "takes exactly one argument" included, so the XPASS would have fired
// on a diagnostic that never counted a single %.
//
// A reject, so there is nothing to run and no `want` to write.
//
//! lrm 9.4.1
//! lrm 9.4.3
//! lrm 9.4.3:1
//! lrm 9.4.1:2
//! reject-only format specifier
//! reject E0810
//! neighbour display_formats.va
`include "disciplines.vams"
module ch09_display_argument_pairing_rejected(p, n);
  inout p, n; electrical p, n;
  analog begin
    $display("%d %d", 1);
    I(p,n) <+ V(p,n);
  end
endmodule
