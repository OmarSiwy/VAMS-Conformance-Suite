// Counts beyond the supported signed-32 reference domain cannot be replaced
// by a smaller count. This is an explicit implementation limitation.
//! lrm 9.13.2
//! reject-only E0816
//! reject fractional or out-of-range
`include "disciplines.vams"
module ch09_rng_count_range_rejected(p, n);
  inout p, n; electrical p, n;
  integer seed;
  real r;
  analog begin
    seed = 7;
    r = $rdist_t(seed, 2147483648.0);
    I(p,n) <+ V(p,n) + r;
  end
endmodule
