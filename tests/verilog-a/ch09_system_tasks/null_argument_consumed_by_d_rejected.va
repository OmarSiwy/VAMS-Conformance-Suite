// VD-101 (specification/Vague_Decisions.md), the refused half. §9.4.1 gives a null
// argument one rendering, "a single space character in the display", and no
// value. `%d` prints a value, so a null argument it consumes has nothing for it
// to print; VerA refuses the pairing by name (E0819, the §9.4.3 conversion
// against its operand) rather than print the space's character code or shift
// the next argument under the conversion.
//
// null_argument_consumed_by_s.va is the legal neighbour: the same call shape
// with `%s`, which prints the null argument's space.
//
//! lrm 9.4.1
//! lrm 9.4.3
//! reject-only E0819
//! neighbour null_argument_consumed_by_s.va
`include "disciplines.vams"
module null_argument_consumed_by_d_rejected(p, n);
  inout p, n; electrical p, n;
  string t;
  analog begin
    $swrite(t, "<%d>", , 7);
    I(p, n) <+ V(p, n);
  end
endmodule
