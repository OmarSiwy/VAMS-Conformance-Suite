// The current integer negation IR wraps to 32 bits. Do not print a truncated
// value under a format wrapper claiming a preserved 64-bit operand.
//! lrm 9.4.5
//! reject-only E0819
`include "disciplines.vams"
module ch09_numeric_string_negation_width_rejected(p,n);
  inout p,n; electrical p,n;
  parameter select = 1;
  string text;
  analog begin
    $sformat(text, "%s", -(select ? 64'hBEBDBCBBBAB9B8B8 : 64'hB6B5B4B3B2B1B0B0));
    I(p,n) <+ V(p,n);
  end
endmodule
