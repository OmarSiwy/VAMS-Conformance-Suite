// Table 9-8 in §9.2 gives $signed digital support and no analog support.
// §9.11 permits four conversions in analog code: $bitstoreal, $realtobits,
// $rtoi and $itor. $signed is not among them.
//
// $signed reinterprets a sized vector's bit pattern as two's complement, which
// presupposes the bit-vector type system of the digital context; an analog
// block has integers and reals. So the call site is the whole claim and there
// is no return value to write a `want` for.
//
// WHERE THE RULE ACTUALLY LIVES. §9.11 permits the four named conversions;
// the prohibition is Table 9-8's analog-context "No" cell. Tables 9-1..9-20
// sits under §9.2 "Categories of System Tasks and Functions" (the nearest
// preceding heading to Table 9-8 in ch9-system.html). Both clauses are cited
// below; 9.2 is the one with teeth.
//
//! lrm 9.2
//! lrm 9.11
//! lrm 9.2:1000
//! reject-only analog context
//! reject E0806
`include "disciplines.vams"
module ch09_atomic_signed_analog_rejected(p, n);
  inout p, n; electrical p, n;
  integer x;
  analog begin
    x = $signed(4'b1011);
    I(p,n) <+ V(p,n) + x;
  end
endmodule
