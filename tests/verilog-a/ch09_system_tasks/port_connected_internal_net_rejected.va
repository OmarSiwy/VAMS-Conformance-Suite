// AMS §9.19 physical264: $port_connected's argument must be a port identifier.
// A declared internal continuous net is not a module port. No undeclared name
// or inappropriate discipline can mask this distinction.
// The distinctive rejection phrase below is the intended diagnostic contract,
// carried by E0822 (it used to be accepted without a diagnostic).
//! lrm 9.19
//! lrm 9.19:5
//! reject-only $port_connected requires a port identifier
`include "disciplines.vams"
module audit_port_connected_internal_net_rejected;
  electrical internal_net;
  integer flag;
  analog flag = $port_connected(internal_net);
endmodule
