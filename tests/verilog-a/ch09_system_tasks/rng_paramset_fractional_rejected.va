// Elaboration must issue the same unsupported diagnostic before calling the
// emitted kernel during constant folding; it must not panic the compiler.
// A.1.9: a paramset needs >= 1 paramset_item_declaration (corrected 2026-10-08)
//! lrm 9.13.2
//! reject-only E0816
//! reject fractional or out-of-range
`include "disciplines.vams"
module ch09_rng_paramset_fractional_rejected(p, n);
  inout p, n; electrical p, n;
  sampled u(p, n);
endmodule
paramset sampled base;
  parameter real unused_item = 0;
  .r = $rdist_erlang(7, 1.5, 3.0, "global");
endparamset
module base(p, n);
  inout p, n; electrical p, n;
  parameter real r = 0;
  analog I(p,n) <+ V(p,n) + r;
endmodule
