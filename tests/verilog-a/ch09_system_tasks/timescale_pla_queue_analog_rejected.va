// The analog-context "No" of Table 9-3 (in §9.2; the tasks are §9.6's):
//     $printtimescale  Yes  No
//     $timeformat      Yes  No
// and §9.6 in full: "Verilog AMS HDL does not extend the timescale tasks
// defined in IEEE Std 1364 Verilog." Both tasks report or set how a TICK COUNT
// is printed, and the analog kernel has no tick — it advances by a
// continuously variable step. That is the same reason Table 9-7 withdraws
// $time and $stime (149) and gives the analog context $abstime in seconds
// instead (abstime.va).
//
// ONE CONSTRUCT, ONE RULE. $printtimescale is the representative of Table 9-3.
// The legal neighbour is timescale_tasks_in_digital_context.va: the same
// task called from a digital `initial` block, Table 9-3's "Yes" column, so the
// pair differs only in the context and the refusal cannot be a blanket refusal
// of the task.
//
// RECONCILER, 2026-10-08. This file used to hold four constructs, one per
// table (9-3, 9-5, 9-6), with abstime.va as its neighbour. The first
// diagnostic ends the compile, so only $printtimescale was ever evidenced, and
// 14_abstime uses none of these tasks. Tables 9-5 and 9-6 moved to
// rc_154_pla_array_analog_rejected.va and
// rc_154_stochastic_queue_analog_rejected.va, each with its digital-context
// neighbour; the `//! lrm 9.8`/`9.9` cites moved with them.
//
// A reject, so there is nothing to run and no `want` to write.
//
//! lrm 9.2
//! lrm 9.6
//! lrm 9.2:1000
//! lrm 9.6:1000
//! reject-only analog context
//! reject E0806
//! neighbour ../../verilog-ams/ch09_system_tasks/timescale_tasks_in_digital_context.va
`include "disciplines.vams"
module ch09_timescale_pla_queue_analog_rejected(p, n);
  inout p, n; electrical p, n;
  analog begin
    $printtimescale;
    I(p,n) <+ V(p,n);
  end
endmodule
