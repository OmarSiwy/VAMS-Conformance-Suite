// §9.17.1 writes the argument as a CONSTANT_expression:
//
//     $discontinuity [ ( constant_expression ) ] ;
//
// "where constant_expression indicates the degree of the discontinuity ...
// $discontinuity(i) implies a discontinuity in the i'th derivative of the
// constitutive equation". The degree is a property of the model's structure —
// which derivative of the constitutive equation steps — not of the operating
// point, so it cannot be read off a node voltage. `V(p,n) > 0.5 ? 1 : 0` is
// a perfectly ordinary analog expression and a perfectly illegal degree.
//
// discontinuity.va is the legal neighbour: it branches on V(p,n) to choose
// BETWEEN two calls, each with a constant degree. That is allowed; computing
// the degree is not.
//
// A reject, so there is nothing to run and no `want` to write.
//
//! lrm 9.17.1
//! lrm 9.17.1:2
//! reject-only E0805
//! neighbour discontinuity.va
`include "disciplines.vams"
module ch09_discontinuity_nonconstant_rejected(p, n);
  inout p, n; electrical p, n;
  analog begin
    $discontinuity(V(p,n) > 0.5 ? 1 : 0);
    I(p,n) <+ V(p,n);
  end
endmodule
