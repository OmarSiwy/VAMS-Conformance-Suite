// §9.11 / Table 9-8: `$unsigned  Yes  No`, the mirror of 134. The extension
// §9.11 defines is $bitstoreal and $realtobits and nothing else, so the
// signedness-reinterpretation pair stays digital-only.
//
// Nothing is asserted: an illegal call site has no defined result, and pinning
// one would over-specify a rule the LRM states as "not available here".
//
// WHERE THE RULE ACTUALLY LIVES. §9.11 is a PERMISSION — "Verilog AMS HDL
// extends the conversion functions ... so that $bitstoreal and $realtobits can
// be used in the analog context" — and forbids nothing on its own. The
// prohibition is Table 9-8's analog-context "No" cell, and every Table 9-1..9-20
// sits under §9.2 "Categories of System Tasks and Functions" (the nearest
// preceding heading to Table 9-8 in ch9-system.html). Both clauses are cited
// below; 9.2 is the one with teeth.
//
//! lrm 9.2
//! lrm 9.11
//! lrm 9.2:1000
//! reject-only analog context
//! reject E0806
`include "disciplines.vams"
module ch09_atomic_unsigned_analog_rejected(p, n);
  inout p, n; electrical p, n;
  integer x;
  analog begin
    x = $unsigned(4'b1011);
    I(p,n) <+ V(p,n) + x;
  end
endmodule
