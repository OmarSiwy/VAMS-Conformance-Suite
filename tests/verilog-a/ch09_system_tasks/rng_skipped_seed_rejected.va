// Skipping evaluation does not relax a call's static signature or scope.
//! lrm 4.2.3
//! lrm 9.13.2
//! lrm 9.13.2:3
//! reject-only E0816
//! reject seed argument shall be an integer
`include "disciplines.vams"
module ch09_rng_skipped_seed(p,n);
  inout p,n; electrical p,n;
  integer seed;
  real value;
  analog begin
    seed=7;
    value=0 && $rdist_exponential(1.5,1);
    I(p,n)<+V(p,n);
  end
endmodule
