// §9.17.3 Syntax 9-12 puts one of two things in the second position: a
// `string` ("When the second argument is a string, it refers to a built-in
// function of the simulator") or an `analog_function_identifier` ("the second
// argument of the $limit() function may be an identifier referring to a
// user-defined analog function"). A number is neither, so the call matches no
// form of the syntax and is refused (E0891).
//
// The unknown-STRING case is different and legal: "If the string refers to an
// unknown or unsupported function, the simulator is responsible for
// determining the appropriate limiting algorithm, just as if no string had been
// supplied" (227_limit_unknown_algorithm_returns_probe, W0853). The legal twin
// of this file is 226_limit_pnjlim_internal_node_honoured.
//
//! lrm 9.17.3
//! reject-only E0891
//! reject second argument is neither a string nor an analog function
`include "disciplines.vams"
module ch09_limit_numeric_algorithm_rejected(p, n);
  inout p, n; electrical p, n, a;
  real vd;
  analog begin
    vd = $limit(V(a,n), 0.025, 0.705018);
    I(p,a) <+ V(p,a) / 100.0;
    I(a,n) <+ 1e-14 * (exp(vd / 0.025) - 1.0);
  end
endmodule
