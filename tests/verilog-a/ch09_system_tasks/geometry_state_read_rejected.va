// §6.3.3 requires a constant expression for a named parameter value
// assignment, also for the implicit §6.3.6 system parameters. V(p) is an
// operating-point read (§4.4), so a position cannot track it during a solve.
// geometry_parameter_sweep.va is the legal neighbour: its expressions read
// model-card parameters, which are fixed throughout a simulation.
//! lrm 6.3.3
//! lrm 6.3.6
//! reject-only E0363
//! neighbour geometry_parameter_sweep.va
`include "disciplines.vams"
module geometry_dynamic_top(p);
  inout p; electrical p;
  geometry_dynamic_child #(.$xposition(V(p))) child();
endmodule
module geometry_dynamic_child;
  analog $display("x=%g", $xposition);
endmodule
