// §9.4.1: "The special character string %% indicates the display of the
// percent sign character (%)"; Table 9-21 (§9.4.2) lists `%%`, two
// characters. A flag, width or precision between them makes something that
// is no escape of Table 9-21 and no format specification of Tables 9-22 and
// 9-23. §9.4.3's grant to the real conversions, "the full formatting
// capabilities available in the C language", gives it no meaning either:
// C11 7.21.6.1p8 says of `%` "The complete conversion specification shall be
// %%", so `%5%` is undefined in C.
//
// Before #42 lowering counted `%5%` as consuming nothing while the device
// translation gave it an argument, so the two disagreed on which argument
// every later conversion took. Now it is refused, E0826, in each spelling:
// a width, a flag, a precision, and the '#' flag (which is E0826 here and not
// E0825: the specification is refused before its flag is judged).
//
// The legal neighbour is percent_escape_prints_one_percent.va: `%%`
// with nothing between the two characters prints one `%`.
//
// A reject, so there is nothing to run and no `want` to write.
//
//! lrm 9.4.2
//! reject-only E0826
//! neighbour percent_escape_prints_one_percent.va
`include "disciplines.vams"
module s01_percent_escape_with_width_rejected(p, n);
  inout p, n; electrical p, n;
  analog begin
    $strobe("%5%");
    $strobe("%-%");
    $strobe("%.2%");
    $strobe("%#%");
    I(p,n) <+ V(p,n);
  end
endmodule
