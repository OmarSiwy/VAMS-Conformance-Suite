// An engine limit, not a language rule. §2.8.3: "A name following the $ is
// interpreted as a system task or a system function", and §12.32 lets a VPI
// application define any such name. VerA spells some of its own internal
// calls as `$` names (specification/Vague_Decisions.md), and a source call with one of
// those spellings used to reach code built for VerA's own arguments: the
// compile aborted on an index out of bounds. It is refused where it is
// written with E1014, which names the reservation.
//
// The legal neighbour is any other unregistered name: `$sampler` in
// ch12_vpi_routines/analog_systf_sampler_call.va compiles with W0852 and
// is handed to a VPI host.
//
//! reject-only E1014
//! neighbour ../../verilog-ams/ch12_vpi_routines/analog_systf_sampler_call.va
`include "disciplines.vams"
module reserved_system_function_name_rejected(p, n);
  inout p, n; electrical p, n;
  real r;
  analog begin
    r = $held_real(1.0);
    I(p, n) <+ r * V(p, n);
  end
endmodule
