// §9.17.3, the one rule the user-defined-limiter form adds that no other form
// of $limit has: "The arguments of the user-defined function shall ALL be
// declared input."
//
// The reason is in the sentences before it. The simulator, not the model,
// supplies those arguments — the access function value for this iteration, the
// value $limit returned on the previous one, and then whatever tail the call
// site passed. They are the solver's state handed inward. An `output` formal
// would let the limiter write back into the solver's own iteration history
// mid-Newton-step, and nothing in §9.17.3 defines what that would mean.
//
// limit_user_function.va is the same function with all three formals
// declared input, and is legal.
//
// A reject, so there is nothing to run and no `want` to write. The pin is E0814,
// the code the rule got when the third form landed; the sentence itself is in the
// diagnostic's note.
//
//! lrm 9.17.3
//! lrm 9.17.3:8
//! reject-only E0814
//! neighbour limit_user_function.va
`include "disciplines.vams"
module ch09_limit_user_function_output_arg_rejected(p, n);
  inout p, n; electrical p, n;
  real limited;
  analog function real mylim;
    input vnew, vold;
    output vcrit;
    real vnew, vold, vcrit;
    begin
      mylim = vnew;
      vcrit = vnew;
    end
  endfunction
  analog begin
    limited = $limit(V(p,n), mylim, 0.7);
    I(p,n) <+ limited;
  end
endmodule
