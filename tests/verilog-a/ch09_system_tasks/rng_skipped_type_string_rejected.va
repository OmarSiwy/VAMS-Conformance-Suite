// Skipping evaluation does not relax a call's static signature or scope.
//! lrm 4.2.3
//! lrm 9.13.2
//! lrm 9.13.2:6
//! reject-only E0816
//! reject type_string
`include "disciplines.vams"
module ch09_rng_skipped_type_string(p,n);
  inout p,n; electrical p,n;
  integer seed;
  real value;
  analog begin
    seed=7;
    value=0 && $rdist_exponential(seed,1,"global");
    I(p,n)<+V(p,n);
  end
endmodule
