// §9.17.2: "$bound_step ( expression ) ; where expression is a required
// argument and represents the maximum timestep the simulator can advance. The
// expression argument shall be non-negative."
//
// A negative maximum timestep is not a small bound, it is no bound at all —
// there is no next time point that satisfies it — so the LRM makes the sign a
// hard requirement rather than a clamp. (The LRM DOES clamp in the other
// direction: "If the value is less than the simulator's minimum allowable time
// step, the simulator's minimum time step shall be used instead." That is the
// zero-and-above case and is not what this file tests.)
//
// A reject, so there is nothing to run and no `want` to write.
//
//! lrm 9.17.2
//! lrm 9.17.2:1
//! reject-only E0803
//! neighbour bound_step.va
`include "disciplines.vams"
module ch09_bound_step_negative_rejected(p, n);
  inout p, n; electrical p, n;
  analog begin
    $bound_step(-1e-9);
    I(p,n) <+ V(p,n);
  end
endmodule
