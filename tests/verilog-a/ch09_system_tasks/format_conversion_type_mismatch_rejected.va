// §9.4.3 pairs each consuming conversion with the expression argument after
// the format string; this file writes three pairs whose CONVERSION and
// OPERAND TYPE cannot meet:
//
//     %s over a real     — §9.4.5's reading (the value as a string of 8-bit
//                          ASCII codes) is a rendering VerA does not
//                          implement, so there is no text to print;
//     %c over a string   — Table 9-22's %c displays the low byte of an
//                          INTEGER as a character, and a string is not a
//                          code;
//     %e over a string   — an exponential format needs a numeric field, and
//                          §2.7's integer view of a string is what %d/%b/%o/%h
//                          take, not the real conversions.
//
// Every one of these used to compile HERE and then fail the generated
// device's own build — reported as an engine bug, with no source location.
// The mismatch is the model's, so it is the model that gets the error, at
// the operand.
//
// (%d over a string, %c over an integer and a numeric under %g are the legal
// neighbours and appear all over this suite — check.vh's own transcript line
// is `%s %g %g %d` over string/real/real/integer.)
//
//! lrm 9.4.3
//! reject-only E0819
`include "disciplines.vams"
module ch09_format_conversion_type_mismatch(p, n);
    inout p, n;
    electrical p, n;
    real r;
    string s;

    analog begin
        r = 3.14;
        s = "volt";
        $strobe("as text: %s", r);
        $strobe("as char: %c", s);
        $strobe("as expo: %e", s);
        I(p, n) <+ V(p, n) * 1.0e-3;
    end
endmodule
