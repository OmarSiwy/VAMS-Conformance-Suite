// §9.2 Table 9-7 (the §9.10 functions), the other two "No" rows:
//
//     $realtime  Yes  No
//     $time      Yes  No
//     $stime     Yes  No
//     $abstime   Yes  Yes
//
// $time and $stime are timescale TICK counts, integer-valued in the units of
// the enclosing `timescale. The analog kernel has no tick — it advances by a
// continuously variable step the solver chooses — so there is no integer for
// them to return, which is why §9.10 adds $abstime "that can be used from the
// analog and digital contexts" and gives it seconds. abstime.va is the
// positive and pins exactly that: seconds, not ticks.
//
// $realtime gets its own file (148) because §9.10 backs its row with a prose
// deprecation note as well as the table. These two rest on the table alone.
//
// A reject, so there is nothing to run and no `want` to write. Both names are
// in one file because they are one rule; the first diagnostic ends the compile.
//
// WHERE THE RULE ACTUALLY LIVES. §9.10's prose says nothing about $time or
// $stime — it only adds $abstime. The prohibition is Table 9-7's analog-context
// "No" cells, and every Table 9-1..9-20 sits under §9.2 "Categories of System
// Tasks and Functions". Both are cited; 9.2 is the one with teeth.
//
//! lrm 9.2
//! lrm 9.10
//! lrm 9.2:1000
//! reject-only analog context
//! reject E0806
//! neighbour abstime.va
`include "disciplines.vams"
module ch09_time_stime_analog_rejected(p, n);
  inout p, n; electrical p, n;
  integer a, b;
  analog begin
    a = $time;
    b = $stime;
    I(p,n) <+ V(p,n) + a + b;
  end
endmodule
