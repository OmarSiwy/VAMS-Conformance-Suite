// Skipping evaluation does not relax a call's static signature or scope.
//! lrm 4.2.3
//! lrm 9.13.2
//! reject-only E0816
//! reject takes 2 arguments
`include "disciplines.vams"
module ch09_rng_skipped_arity(p,n);
  inout p,n; electrical p,n;
  integer seed;
  real value;
  analog begin
    seed=7;
    value=0 && $rdist_exponential(seed);
    I(p,n)<+V(p,n);
  end
endmodule
