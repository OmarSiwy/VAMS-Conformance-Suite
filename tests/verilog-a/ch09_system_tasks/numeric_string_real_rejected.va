// The numeric ASCII implementation currently accepts integral operands only.
// A real must be diagnosed in string tasks as it is in display/file tasks;
// do not emit uncompilable Zig or silently choose a real bit interpretation.
//! reject-only E0819
`include "disciplines.vams"
module ch09_numeric_string_real_rejected(p, n);
  inout p, n; electrical p, n;
  string text;
  analog begin
    $sformat(text, "%s", 1.5);
    I(p,n) <+ V(p,n);
  end
endmodule
