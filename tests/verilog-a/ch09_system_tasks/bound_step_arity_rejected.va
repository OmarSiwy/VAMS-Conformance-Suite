// §9.17.2: "The general form is $bound_step ( expression ) ; where expression
// is a REQUIRED argument". Unlike $discontinuity, whose argument the grammar
// brackets as optional, $bound_step has no zero-argument form: the task IS the
// bound, and without one it says nothing.
//
// A reject, so there is nothing to run and no `want` to write.
//
//! lrm 9.17.2
//! lrm 9.17.2:1001
//! neighbour bound_step.va
//! reject-only E0802
`include "disciplines.vams"
module ch09_bound_step_arity_rejected(p, n);
  inout p, n; electrical p, n;
  analog begin
    $bound_step();
    I(p,n) <+ V(p,n);
  end
endmodule
