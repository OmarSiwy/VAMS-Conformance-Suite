// IEEE 1364-2005 §17.11.1, imported by AMS §9.14, requires 63 for the
// 128-bit unsigned value 2**63. The current analog carrier cannot preserve
// that unsigned value at 128 bits: its i64 bit pattern is negative, but
// sign-extending it would change the value. Refuse by the existing named
// carrier diagnostic, never report 128. The legal carrier neighbour is
// clog2_unsigned_width.va's 64-bit high-bit and 128-bit signed -1 cases.
//! lrm 9.14
//! reject-only E0130
//! neighbour clog2_unsigned_width.va
`include "disciplines.vams"
module reject_clog2_wide_unsigned_carrier;
  integer result;
  analog result = $clog2(128'h8000000000000000);
endmodule
