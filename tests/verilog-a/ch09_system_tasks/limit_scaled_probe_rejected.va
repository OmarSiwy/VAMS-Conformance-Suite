// §9.17.3 Syntax 9-12 gives every form of the call the same first argument:
//
//   limit_call ::= $limit ( access_function_reference )
//     | $limit ( access_function_reference , string , arg_list )
//     | $limit ( access_function_reference , analog_function_identifier , arg_list )
//
// and the prose names it again: "It returns a real value that is derived from
// its first argument (the access function reference, such as a branch
// voltage)". `type*V(a,n)` is an expression over an access function, not an
// access function reference. A.8.2's generic analog_system_function_call takes
// any analog_expression for every system function; the clause's own syntax is
// what narrows `$limit`'s. So this is refused (E0891) rather than compiled and
// left unlimited. The legal spelling is the twin,
// 231_limit_polarity_sign_argument_honoured: scale the result, pass the polarity
// as the trailing sign argument.
//
//! lrm 9.17.3
//! reject-only E0891
//! reject first argument is not an access function reference
`include "disciplines.vams"
module ch09_limit_scaled_probe_rejected(p, n);
  inout p, n; electrical p, n, a;
  parameter integer type = -1;
  real vd;
  analog begin
    vd = $limit(type * V(a,n), "pnjlim", 0.025, 0.705018);
    I(p,a) <+ V(p,a) / 100.0;
    I(a,n) <+ type * 1e-14 * (exp(vd / 0.025) - 1.0);
  end
endmodule
