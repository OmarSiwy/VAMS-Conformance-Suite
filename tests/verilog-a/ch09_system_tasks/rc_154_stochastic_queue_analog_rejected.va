// The analog-context "No" of Table 9-6 (in §9.2; the §9.9 stochastic analysis
// tasks): $q_initialize, $q_remove, $q_exam, $q_add and $q_full are "No" in
// the analog context, and §9.9 in full: "Verilog AMS HDL does not extend the
// stochastic analysis tasks defined in IEEE Std 1364 Verilog."
//
// ONE CONSTRUCT, ONE RULE. $q_initialize(q_id, q_type, max_length, status),
// the IEEE 1364 §17.6 task form stochastic_queue_in_digital_context.va
// calls from a digital `initial` block (Table 9-6's "Yes" column), is called
// here from the analog block with an analog-owned integer status. The legal
// neighbour is that file, so the pair differs in the context and the refusal
// cannot be a blanket refusal of the task.
//
// Split out of timescale_pla_queue_analog_rejected.va by the reconciler,
// 2026-10-08: there the queue call came last and the first diagnostic ended
// the compile, so this rule was never evidenced (and it was written as a
// three-argument function call, which is not §17.6's form either).
//
// A reject, so there is nothing to run and no `want` to write.
//
//! lrm 9.9
//! lrm 9.9:1000
//! lrm 9.2
//! lrm 9.2:1000
//! reject-only analog context
//! reject E0806
//! neighbour ../../verilog-ams/ch09_system_tasks/stochastic_queue_in_digital_context.va
`include "disciplines.vams"
module rc_154_stochastic_queue_analog_rejected(p, n);
  inout p, n; electrical p, n;
  integer status;
  analog begin
    $q_initialize(1, 1, 2, status);
    I(p,n) <+ V(p,n);
  end
endmodule
