// The analog-context "No" of Table 9-5 (in §9.2; the §9.8 PLA modeling tasks): all
// sixteen $async/$sync array and plane spellings are "No" in the analog
// context, and §9.8 in full: "Verilog AMS HDL does not extend the PLA modeling
// tasks defined in IEEE Std 1364 Verilog."
//
// ONE CONSTRUCT, ONE RULE. $sync$and$array, the call
// pla_array_in_digital_context.va makes from a digital `initial` block
// (Table 9-5's "Yes" column), is made here from the analog block. The legal
// neighbour is that file, so the pair differs in the context and the refusal
// cannot be a blanket refusal of the task. The operands are analog-owned
// integer variables, so no digital variable is written from the analog block
// and the context is the only rule the call can break.
//
// Split out of timescale_pla_queue_analog_rejected.va by the reconciler,
// 2026-10-08: there the PLA call followed another refused task and the first
// diagnostic ended the compile, so this rule was never evidenced.
//
// A reject, so there is nothing to run and no `want` to write.
//
//! lrm 9.8
//! lrm 9.8:1000
//! lrm 9.2
//! lrm 9.2:1000
//! reject-only analog context
//! reject E0806
//! neighbour ../../verilog-ams/ch09_system_tasks/pla_array_in_digital_context.va
`include "disciplines.vams"
module rc_154_pla_array_analog_rejected(p, n);
  inout p, n; electrical p, n;
  integer pers [1:2];
  integer ins, outs;
  analog begin
    $sync$and$array(pers, ins, outs);
    I(p,n) <+ V(p,n);
  end
endmodule
