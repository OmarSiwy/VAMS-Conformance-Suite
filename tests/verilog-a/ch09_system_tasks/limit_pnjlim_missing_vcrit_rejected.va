// §9.17.3: "Two additional arguments to the $limit() function are required
// when the second argument to the limit function is the string "pnjlim"." The
// two are vte and vcrit (Table E.2).
//
// THE CALL BELOW SUPPLIES ONE OF THE TWO. args.len is 3 and pnjlim requires 4,
// so the call is short by vcrit and must be diagnosed; E0809 is VerA's code for
// a $limit missing an argument its algorithm requires. annex_e_spice/
// limit_pnjlim_missing_args.va has the same 3-argument form (vte present,
// vcrit missing); this file carries the §9.17.3:1002 exact cite, and
// limit_pnjlim_internal_node_honoured.va is the neighbour that supplies
// both.
//
// The probe is an internal net so no port-limiting refusal can mask the arity
// question.
//
//! lrm 9.17.3
//! lrm 9.17.3:1002
//! reject-only E0809
//! neighbour limit_pnjlim_internal_node_honoured.va
`include "disciplines.vams"
module ch09_limit_pnjlim_missing_vcrit(p);
  inout p; electrical p; electrical mid; real limited;
  analog begin
    limited = $limit(V(mid), "pnjlim", 0.025);
    I(mid, p) <+ (limited - V(p)) / 1.0;
  end
endmodule
