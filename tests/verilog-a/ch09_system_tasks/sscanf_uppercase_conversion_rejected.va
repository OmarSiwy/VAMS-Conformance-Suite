// §9.5.4.2's conversion codes are lower case, and the case matters.
//
// Table 9-22 spells every DISPLAY conversion twice — "%h or %H", "%d or %D",
// "%l or %L" — so a display format is case-insensitive by construction.
// §9.5.4.2's code table for $fscanf/$sscanf spells each code ONCE, in lower
// case, and adds the escape clause: "if an invalid conversion character follows
// the %, the results of the operation are implementation dependent".
//
// Implementation dependent is not a licence to do nothing. VerA's scanner
// compares the raw byte, so an accepted-but-unimplemented `%D` matched no input
// and assigned no item: the call returned 0, the destination kept whatever it
// had, and the user got no diagnostic to explain either. Of the results the
// clause permits, the one worth having is the one that is visible at compile
// time — and this one is statically determinable, because the format is a
// literal. So: reject.
//
// The reject substring is `conversion`, from E0813's "does not support the
// conversion `%D`". The lower-case neighbour is sscanf.va, whose `%d` on
// "42" must keep assigning 42 and returning 1; a compiler that implements this
// rule by refusing the letter rather than its case fails that fixture.
//
// A reject, so there is nothing to run and no `want` to write.
//
//! lrm 9.5.4.2
//! reject-only conversion
//! reject E0813
//! neighbour sscanf.va
`include "disciplines.vams"
module ch09_sscanf_uppercase_conversion_rejected(p, n);
  inout p, n; electrical p, n;
  integer code, value;
  analog begin
    code = $sscanf("42", "%D", value);
    I(p,n) <+ V(p,n) + code + value;
  end
endmodule
