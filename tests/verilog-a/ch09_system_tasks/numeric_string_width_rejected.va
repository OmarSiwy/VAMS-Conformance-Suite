// Numeric string conversion must not guess a width lost by the analog IR.
//! reject-only E0819
`include "disciplines.vams"
module ch09_numeric_string_width_rejected(p,n);
  inout p,n; electrical p,n;
  parameter wide = 64'h4142434445464748;
  string text;
  analog begin
    $sformat(text, "%s", wide);
    I(p,n) <+ V(p,n);
  end
endmodule
