// §9.4.3 gives the real conversions "the full formatting capabilities
// available in the C language", and C bounds no field width or precision. A
// device has to: each field is composed in a buffer its width and precision
// size at compile time, and its real conversion counts digit positions as
// 32-bit integers. VerA's limit is 2^30 = 1073741824 for each
// (specification/Vague_Decisions.md §7, "analog-context format field width
// and precision"); past it is E0828.
//
// Before #45 a width that overflowed parsing became the largest usize, and
// the scratch size computed from it (width + 2, precision + 320) overflowed:
// a panic in a safe compiler build, a garbage buffer size in a fast one.
//
// Each line is refused on its own, E0828:
//   %1073741825d               a width one past 2^30
//   %.1073741825f              a precision one past 2^30
//   %99999999999999999999999e  a width no u64 holds (the old overflow)
//
// The legal neighbour is sformat_field_width_over_4096.va: widths and a
// precision of 4097 to 6000 compile and print. The limit itself (2^30
// accepted, 2^30 + 1 refused) is pinned by lowering's own test, which needs
// no gigabyte buffer to say so.
//
// A reject, so there is nothing to run and no `want` to write.
//
//! lrm 9.4.3
//! reject-only E0828
//! neighbour sformat_field_width_over_4096.va
`include "disciplines.vams"
module s01_format_field_past_its_limit_rejected(p, n);
  inout p, n; electrical p, n;
  analog begin
    $strobe("%1073741825d", 1);
    $strobe("%.1073741825f", 1.5);
    $strobe("%99999999999999999999999e", 1.5);
    I(p,n) <+ V(p,n);
  end
endmodule
