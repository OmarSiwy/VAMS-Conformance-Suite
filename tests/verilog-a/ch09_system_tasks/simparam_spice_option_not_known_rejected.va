// §9.15: "If param_name is not known, and the optional expression is not
// supplied, then an error is generated."
//
// Which names are known is implementation-defined ("There is no fixed list of
// simulation parameters"). VerA publishes three SPICE `.options` tolerances,
// "reltol", "abstol" and "vntol" (specification/Vague_Decisions.md, §9.15), and no other
// option. "chgtol" is a SPICE option too, so it is the closest legal-looking
// name the set leaves out, and the bare call is the error.
//
// The legal neighbour is simparam_newton_tolerances_host_written.va: the same
// bare call on a published name compiles and returns the host's value.
//! lrm 9.15
//! reject-only E0811
//! reject simulation parameter is not known
//! neighbour simparam_newton_tolerances_host_written.va
`include "disciplines.vams"
module ch09_simparam_spice_option_not_known_rejected(p, n);
  inout p, n; electrical p, n;
  analog I(p,n) <+ $simparam("chgtol") * V(p,n);
endmodule
