// §4.4: nets have no value of their own — "access functions are used ... to
// access signals on nets, ports and branches" — so a bare net name is not an
// expression a display task can render. §9.4.1's arguments are ordinary
// expressions; the names whose argument really IS a net reference are §9.19's
// `$port_connected` and §9.20's alias functions (binding_detection.va and
// node_alias_calls.va pin those), and `$strobe` is not among them.
//
// This file exists because the net-reference argument path was applied to
// EVERY system task: `$strobe("%g", p)` compiled and printed p's node_order
// INDEX — a small integer that reads like a plausible voltage, with nothing
// to say a probe was forgotten. The right answer is the same E0315 a bare net
// gets in any other expression position, whose help text says to probe it.
//
//! lrm 4.4
//! lrm 9.4.1
//! reject-only E0315
//! neighbour binding_detection.va
//! neighbour ../../verilog-ams/ch09_system_tasks/node_alias_calls.va
`include "disciplines.vams"
module ch09_net_name_display_argument(p, n);
    inout p, n;
    electrical p, n;

    analog begin
        $strobe("node voltage = %g", p);
        I(p, n) <+ V(p, n) * 1.0e-3;
    end
endmodule
