// §9.15: "$simparam$str is similar to $simparam", and for $simparam "If
// param_name is not known, and the optional expression is not supplied, then
// an error is generated." $simparam$str has no optional expression (Syntax
// 9-10), and Table 9-28 lists the names it supports, so a literal name
// outside the table is that error (E0811) rather than a silent "".
// simparam_str_cwd_and_analysis_name.va is the legal neighbour: Table 9-28's
// "cwd" and "analysis_name" in the same position are read.
//! lrm 9.15
//! reject-only E0811
//! reject `"working_directory"` is not a Table 9-28 string parameter
//! neighbour simparam_str_cwd_and_analysis_name.va
`include "disciplines.vams"
module simparam_str_unknown_name_rejected(p, n);
  inout p, n; electrical p, n;
  string s;
  analog begin
    s = $simparam$str("working_directory");
    I(p, n) <+ 0.0 * V(p, n);
  end
endmodule
