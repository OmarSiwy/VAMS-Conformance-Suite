// Numeric string conversion must not guess a width lost by the analog IR.
//! reject-only E0819
`include "disciplines.vams"
module ch09_numeric_string_arithmetic_width_rejected(p,n);
  inout p,n; electrical p,n;

  string text;
  analog begin
    $sformat(text, "%s", 64'h4142434445464748 + 64'd0);
    I(p,n) <+ V(p,n);
  end
endmodule
