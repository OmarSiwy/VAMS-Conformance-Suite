// §9.17.3: "One additional argument to the $limit() function is required when
// the second argument to the limit function is the string "fetlim": the third
// argument to $limit() is generally the threshold voltage of the MOS
// transistor."
//
// "is required" is normative, so the call below is not a legal $limit() call:
// it names "fetlim" and supplies no third argument. E0809 is VerA's code for a
// $limit missing an argument its algorithm requires.
//
// "fetlim" is not the unknown-string case. §9.17.3 says an unknown or
// unsupported function name leaves the algorithm to the simulator "just as if
// no string had been supplied"; "fetlim" is one of the two algorithms the
// clause names, and naming it is what triggers the requirement violated here.
//
// THE PROBE IS AN INTERNAL NET so the arity is the only thing left to object
// to: a $limit on a module port is one a simulator may decline outright.
// The legal neighbour supplies the required third argument.
//
//! lrm 9.17.3
//! lrm 9.17.3:1003
//! reject-only E0809
//! neighbour limit_fetlim_with_vth.va
`include "disciplines.vams"
module ch09_limit_fetlim_missing_vth(p);
  inout p; electrical p; electrical mid; real limited;
  analog begin
    limited = $limit(V(mid), "fetlim");
    I(mid, p) <+ (limited - V(p)) / 1.0;
  end
endmodule
