// §9.17.1 gives the grammar as
//
//     $discontinuity [ ( constant_expression ) ] ;
//
// — brackets around ONE optional argument. The argument is "the degree of the
// discontinuity", a single number: $discontinuity(0) a step in the equation,
// $discontinuity(1) a step in its slope. There is no two-argument form for a
// hint to carry, so a second argument is not a wrong degree, it is not a legal
// call.
//
// A reject, so there is nothing to run and no `want` to write.
//
//! lrm 9.17.1
//! reject-only E0804
`include "disciplines.vams"
module ch09_discontinuity_arity_rejected(p, n);
  inout p, n; electrical p, n;
  analog begin
    $discontinuity(0, 1);
    I(p,n) <+ V(p,n);
  end
endmodule
