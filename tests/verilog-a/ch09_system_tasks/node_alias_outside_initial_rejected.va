// §9.20, one of six flat "shall be an error" rules for the alias functions:
//
//   "It shall be an error for the $analog_node_alias() and $analog_port_alias()
//    system functions to be used outside the analog initial block."
//
// The rule has a reason the next sentence gives: "Along with their enclosing
// analog initial block scopes, both system functions shall be re-evaluated each
// sweep point of a dc sweep as needed." Aliasing rewires the circuit matrix —
// the aliased node "shall refer to the same circuit matrix position" — so it is
// a topology operation, and topology is fixed between solves. An ordinary
// analog block runs inside the Newton loop, where it cannot be.
//
// This is the cheapest of the six to write and the only structural difference
// from the legal analog_node_alias.va is the keyword `initial`.
//
// A reject, so there is nothing to run and no `want` to write.
//
//! lrm 9.20
//! lrm 9.20:7
//! reject-only analog initial
//! reject E0812
//! neighbour ../../verilog-ams/ch09_system_tasks/analog_node_alias.va
`include "disciplines.vams"
module ch09_node_alias_outside_initial_rejected(p, n);
  inout p, n; electrical p, n;
  electrical local_node; integer status;
  analog begin
    status = $analog_node_alias(local_node, "$root.top.a");
    I(p,n) <+ V(p,n) + status;
  end
endmodule
