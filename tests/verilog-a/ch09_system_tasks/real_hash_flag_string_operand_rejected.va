// §9.4.3 pairs each consuming conversion with the expression argument after
// the format string, and Table 9-23's %e/%f/%g are "used for real numbers".
// '#' is one of C11 7.21.6.1p6's flags, so `%#g` and `%#e` ARE %g and %e:
// a string operand under them has no numeric field to format, E0819, the
// same refusal format_conversion_type_mismatch_rejected.va pins for a
// bare %e.
//
// Before #41 lowering's scanner did not know '#', read it as the conversion
// letter, found no rule for a letter '#', and let both lines through; the
// device then printed the text "volt" followed by a literal "g" / "e".
//
// The legal neighbour is real_hash_flag_g_keeps_trailing_zeros.va:
// the same `%#g` over a real operand compiles and prints C's alternative
// form.
//
// A reject, so there is nothing to run and no `want` to write.
//
//! lrm 9.4.3
//! reject-only E0819
//! neighbour real_hash_flag_g_keeps_trailing_zeros.va
`include "disciplines.vams"
module s01_real_hash_flag_string_operand_rejected(p, n);
  inout p, n; electrical p, n;
  string s;
  analog begin
    s = "volt";
    $strobe("as %#g", s);
    $strobe("as %#e", s);
    I(p,n) <+ V(p,n);
  end
endmodule
