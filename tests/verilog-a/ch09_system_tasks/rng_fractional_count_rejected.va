// AMS permits real df; the integer-count reference has no established
// fractional extension here. Reject explicitly rather than truncating it.
//! lrm 9.13.2
//! reject-only E0816
//! reject fractional or out-of-range
`include "disciplines.vams"
module ch09_rng_fractional_count_rejected(p, n);
  inout p, n; electrical p, n;
  integer seed;
  real r;
  analog begin
    seed = 7;
    r = $rdist_chi_square(seed, 1.5);
    I(p,n) <+ V(p,n) + r;
  end
endmodule
