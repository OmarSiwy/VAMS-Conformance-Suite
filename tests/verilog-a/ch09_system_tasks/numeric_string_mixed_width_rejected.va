// Numeric string conversion must not guess a width lost by the analog IR.
//! reject-only E0819
`include "disciplines.vams"
module ch09_numeric_string_mixed_width_rejected(p,n);
  inout p,n; electrical p,n;

  string text;
  analog begin
    $sformat(text, "%s", 1 ? 8'shff : 64'h4142434445464748);
    I(p,n) <+ V(p,n);
  end
endmodule
