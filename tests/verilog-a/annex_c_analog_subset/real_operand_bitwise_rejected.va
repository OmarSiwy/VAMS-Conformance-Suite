// C.5 Expressions: "The expressions defined in Clause 4 are applicable to both
// Verilog-AMS HDL and Verilog-A with the following exception: The case
// equality operators (===, !==) are not supported in Verilog-A."
//
// Two halves. The exception is the optional subset's (CLAUSE-AUDIT §5.2), and
// VerA targets full Verilog-AMS, where §7.3.2 supports both operators — that is
// why case_equality_accepted.va and case_inequality.va run them. The
// INCLUSION is not the subset's: it says Clause 4 binds a Verilog-A module
// exactly as it binds a Verilog-AMS one, prohibitions included. Its positive
// side is 10/17 (Clause 4 operators computing their values in an analog-only
// module); this file is its reject side — a Clause 4 prohibition met in a
// module that uses nothing outside the Verilog-A subset, so the only rule that
// can refuse it is Clause 4's own.
//
// The prohibition is §4.2.1's, both sentences: "The operators shown in Table
// 4-2 are legal when applied to real operands. All other operators are
// considered illegal when used with real operands." Table 4-2 lists no bitwise
// operator and no shift, so `1.5 | 2` and `0.5 >> 1` are illegal wherever
// Clause 4 applies — which C.5 says is everywhere. (ch04_expressions/
// real_operand_illegal_operator_rejected.va pins the same rule from the
// Clause 4 side with `&` and `<<`; the operators here are the other member of
// each pair, so the two files together cover both tables.)
//
// VerA answers E0322 for each; the code is pinned. The first diagnostic does
// not end the compile, but one arm suffices for the rule and the second line
// widens what the file exercises.
//
//! lrm C.5
//! lrm 4.2.1
//! lrm 4.2.1:1
//! reject-only E0322
//! neighbour ../../verilog-ams/annex_c_analog_subset/case_equality_accepted.va
//! neighbour ../../verilog-ams/annex_c_analog_subset/case_inequality.va
`include "disciplines.vams"
module annex_c_real_operand_bitwise_rejected(p, n);
    inout p, n;
    electrical p, n;
    integer ored, shifted;

    analog begin
        ored = 1.5 | 2;            // illegal: | is not in Table 4-2
        shifted = 0.5 >> 1;        // illegal: >> is not in Table 4-2
        I(p, n) <+ V(p, n) + ored + shifted;
    end
endmodule
