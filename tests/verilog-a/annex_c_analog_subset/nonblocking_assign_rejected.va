// Annex C.7, bullet 1: "No digital behavior or events are supported in
// Verilog-A." The nonblocking assignment `variable_lvalue <= expression` is
// A.6.2 `nonblocking_assignment`, an alternative of the DIGITAL `statement`
// production; it has no counterpart in A.6.4's `analog_statement`.
//
// The cite is §5.7, "Analog procedural assignments", whose Syntax 5-7 gives the
// one procedural assignment an analog block admits:
//
//     scalar_analog_variable_lvalue = analog_expression
//
// and no other. (§5.6 is "Contribution statements", a neighbour: it defines
// `<+`, not `=`. A.6.4's `analog_statement` derives three assigning forms in
// all — analog_procedural_assignment, contribution_statement and
// indirect_contribution_statement (§5.6.7) — none of them `<=`.)
//
// ch07_mixed_signal/macro_process_runs_after_nba.va writes `<=` in an
// `always` block, where it is legal and runs. This fixture puts `<=` in an
// `analog` block, where nothing else is out of subset and the diagnostic can
// only be about the operator.
//
//! lrm C.7
//! lrm 5.7
//! lrm A.6.2
//! lrm A.6.2:1000
//! lrm A.6.4
//! lrm A.6.4:1000
//! reject-only E0214
//! neighbour ../../verilog-ams/ch07_mixed_signal/macro_process_runs_after_nba.va
`include "disciplines.vams"
module annex_c_nonblocking_assign_rejected(p);
    inout p;
    electrical p;
    integer state;

    analog begin
        state <= 1;
        I(p) <+ V(p);
    end
endmodule
