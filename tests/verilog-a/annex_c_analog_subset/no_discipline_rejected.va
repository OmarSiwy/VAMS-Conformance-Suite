// Annex C.4, bullet 3: "All Verilog-A modules shall have a discipline defined
// for each module." This one defines none for its only port.
//
// Nothing is asserted, and that is the point: with no discipline there is no
// nature bound to p, so there is no `V` access function and no potential to
// probe. The previous version asserted V(p) == 0.25 against the testbench bias —
// that number is VerA's implicit-electrical fallback, not a rule, so a
// CONFORMING compiler failed the fixture and only VerA passed it. The only
// conforming outcome here is a diagnostic.
//
//! lrm C.4
//! lrm C.4:2
//! lrm 3.8
//! reject-only discipline
`include "disciplines.vams"
module annex_c_no_discipline_rejected(p);
    inout p;
    analog I(p) <+ V(p);
endmodule
