// A.6.4, `analog_statement`: a bare `disable <named_block>;` inside an analog
// block is an error, because `analog_statement` derives no `disable_statement`.
// (The production itself is in A.6.5, Timing control statements:
// `disable_statement ::= disable hierarchical_task_identifier ; | disable
// hierarchical_block_identifier ;`.)
//
// The rule is A.6.4 alone, NOT C.7. C.7's "no digital behavior or events" does
// not reach `disable`, because A.6.4 explicitly ADMITS it in the analog
// context: `analog_event_statement ::= ... | { attribute_instance }
// disable_statement | ...`, so `@(evt) disable blk;` is legal Verilog-AMS
// analog behavior and legal Verilog-A. VerA's own catalogue says exactly that —
// E0401's explain text spells out the admitted form. The earlier version of
// this comment claimed "killing a named block mid-flight is a control-flow move
// only a digital scheduler can make", which the grammar refutes; the verdict
// survives only because the source below is the bare form.
//
// Its own file rather than an arm of 25: `disable` parses and is caught one
// stage later (E0401, "`disable` is not an analog statement"), and that stage
// does not run at all once a parse error exists — put next to fork/join/wait it
// is silently never reported.
//
//! lrm A.6.4
//! lrm A.6.5
//! lrm A.6.4:1000
//! reject-only E0401
//! reject disable
`include "disciplines.vams"
module annex_c_disable_rejected(p);
    inout p;
    electrical p;
    integer state;

    analog begin : main
        state = 1;
        disable main;
        I(p) <+ V(p);
    end
endmodule
