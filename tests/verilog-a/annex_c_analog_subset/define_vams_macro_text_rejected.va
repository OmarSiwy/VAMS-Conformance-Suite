// C.12's reject side. "The compiler directives of Clause 10 are applicable to
// both Verilog-AMS HDL and Verilog-A" carries Clause 10's prohibitions into the
// subset with its permissions (compiler_directives.va is the positive side).
//
// §10.4 states one in so many words: "To avoid conflicts with predefined
// Verilog-AMS macros (10.5), the `define compiler directive's macro text shall
// not begin with __VAMS_." Syntax 10-3, `text_macro_definition ::= `define
// text_macro_name macro_text`, makes the BODY the target, and the body here is
// __VAMS_ENABLE__, the exact §10.5 name the sentence protects.
//
// ch10_directives/define_vams_macro_text.va pins the rule from Clause 10's
// side; this file is it in a Verilog-A module, under the clause that says
// Clause 10 binds one. VerA answers E0139; the code is pinned.
//
//! lrm C.12
//! lrm 10.4
//! lrm 10.4:1
//! reject-only E0139
//! neighbour compiler_directives.va
`include "disciplines.vams"
`define MY_ENABLE __VAMS_ENABLE__
module annex_c_define_vams_macro_text_rejected(p, n);
    inout p, n;
    electrical p, n;
    analog I(p, n) <+ V(p, n);
endmodule
