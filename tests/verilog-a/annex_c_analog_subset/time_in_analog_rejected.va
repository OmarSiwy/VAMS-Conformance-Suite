// C.11's reject side. "All system tasks and functions in Clause 9 that are
// applicable in the analog context are applicable to Verilog-A" — and the ones
// that are NOT applicable there are not made applicable by being in a
// Verilog-A module. §9.2's Table 9-7 is where that line is drawn for time:
//
//     Function name   Supported in digital context   Supported in analog context
//     $realtime       Yes                            No
//     $time           Yes                            No
//     $stime          Yes                            No
//     $abstime        Yes                            Yes
//
// `$time` is a count of timescale ticks, and an analog block has no tick — the
// solver chooses a continuously variable step — which is why §9.10 adds
// `$abstime` "that can be used from the analog and digital contexts".
// analog_context_system_functions.va is the positive side and reads
// `$abstime` in seconds; this file reads `$time` in the same place.
//
// ch09_system_tasks/time_stime_analog_rejected.va pins the Table 9-7 cell
// from the Clause 9 side; this file puts it under C.11, whose "applicable in the
// analog context" qualifier IS that column. VerA answers E0806, whose message
// names the analog context; the code and the phrase are pinned.
//
//! lrm C.11
//! lrm 9.2
//! lrm 9.10
//! lrm 9.2:1000
//! reject-only E0806
//! reject analog context
//! neighbour analog_context_system_functions.va
`include "disciplines.vams"
module annex_c_time_in_analog_rejected(p, n);
    inout p, n;
    electrical p, n;
    integer ticks;

    analog begin
        ticks = $time;             // illegal: Table 9-7, $time, analog: No
        I(p, n) <+ V(p, n);
    end
endmodule
