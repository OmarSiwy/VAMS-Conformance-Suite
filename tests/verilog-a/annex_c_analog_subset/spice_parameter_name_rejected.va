// C.18's reject side. "Annex E defines the SPICE compatibility for both
// Verilog-A and Verilog-AMS HDL", and Annex E's parameter list for a primitive
// is closed:
//
//     E.3: "Table E.1 shows the required names for primitives, parameters, and
//     ports which are otherwise unnamed in SPICE." Table E.1, `resistor`:
//     parameters r, tc1, tc2.
//
//     §6.3.3: "Parameter assignment by name explicitly links the parameter name
//     and its value. The name shall be the name specified in the instantiated
//     module."
//
// `rsh` is an ordinary Berkeley resistor-model parameter and not on the
// Table E.1 row, so `resistor #(.rsh(50))` names a parameter the instantiated
// primitive does not have and violates the `shall`. spice_primitive.va is
// the positive side (the row's `r`, bound and read back).
//
// annex_e_spice/reject_parameter_name_not_in_table_e1.va pins the same
// composition from Annex E's side, and its header argues why the refusal is
// normative in SOURCE even though Annex E leaves netlist-card parameters to the
// implementation. This file puts it under C.18, in a Verilog-A module. VerA
// answers E0907, whose message names the parameter; both are pinned.
//
//! lrm C.18
//! lrm E.3
//! lrm 6.3.3
//! lrm 6.3.3:1
//! lrm E.1.2
//! lrm E.1.2:2
//! reject-only E0907
//! reject `rsh`
//! neighbour spice_primitive.va
`include "disciplines.vams"
module annex_c_spice_parameter_name_rejected(p, n);
    inout p, n;
    electrical p, n;
    resistor #(.rsh(50)) r1(p, n);  // illegal: rsh is not a Table E.1 resistor parameter
    analog I(p, n) <+ V(p, n) / 1.0e3;
endmodule
