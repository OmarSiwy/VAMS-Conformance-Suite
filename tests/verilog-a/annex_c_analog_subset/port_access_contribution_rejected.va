// C.6 Analog signals: "The signals defined in 5.4 are applicable to both
// Verilog-AMS HDL and Verilog-A." An inclusion with no exception, so it carries
// §5.4's rules into the subset whole — what §5.4 permits (analog_only_device.va
// is the positive side, a §5.4.1 two-terminal probe that must read 1.0) and what
// it forbids.
//
// §5.4.3 is where §5.4 forbids something in so many words:
//
//     "The expression V(<a>) is invalid for ports and nets, where V is a
//      potential access function. The port access function shall not be used
//      on the left side of a contribution operator <+."
//
// `I(<p>)` reads the flow INTO the module through port p; it is a probe of what
// the rest of the circuit does at that port, not a branch this module owns, so
// there is nothing for a contribution to set. The module below is otherwise
// plain Verilog-A — one discipline, one analog block, one legal contribution —
// so the refusal can only come from §5.4.3, which C.6 makes a Verilog-A rule.
//
// ch04_expressions/port_access_lhs_rejected.va pins the same sentence from
// the §4.4/§5.4.3 side; this file exists to put it under C.6, the clause that
// says the rule applies to both languages. VerA answers E0407 "port access
// function cannot be a contribution target"; the code is pinned.
//
// Legal neighbour: rc_34_port_access_read_accepted.va, this module with `I(<p>)`
// read on the right instead of written on the left. (Reconciler, 2026-10-08: the
// neighbour was analog_only_device.va, which never uses a port access, so it
// could not exclude a blanket refusal of `I(<p>)`.)
//
//! lrm C.6
//! lrm 5.4.3
//! lrm 5.4.3:1
//! reject-only E0407
//! neighbour rc_34_port_access_read_accepted.va
`include "disciplines.vams"
module annex_c_port_access_contribution_rejected(p, n);
    inout p, n;
    electrical p, n;

    analog begin
        I(<p>) <+ 1.0e-3;          // illegal: a port access on the left of <+
        I(p, n) <+ V(p, n);
    end
endmodule
