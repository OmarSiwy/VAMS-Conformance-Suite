// §5.10.3.1: "In addition, cross() is not allowed in the repeat and while
// iteration statements. It is allowed in the analog_for statements."
//
// The `while` half; cross_in_repeat_rejected.va is the `repeat` half. A
// `while` body runs a data-dependent number of times per evaluation, so a
// cross() inside it has no single history to detect a crossing in.
// cross_under_genvar_condition.va holds cross() in an analog_for, the form
// the sentence allows, and must keep compiling.
//
// VerA refuses it with E0707, "event control statement under a runtime
// condition or in a loop".
//
//! lrm 5.10.3.1
//! lrm 5.10.3.1:8
//! reject-only E0707
//! neighbour cross_under_genvar_condition.va
`include "disciplines.vams"
module b3_cross_in_while(p);
  inout p; electrical p;
  integer n, i;
  analog begin
    i = 0;
    while (i < 2) begin
      @(cross(V(p), 1)) n = n + 1;                    // illegal: cross() in while
      i = i + 1;
    end
    I(p) <+ 0.0;
  end
endmodule
