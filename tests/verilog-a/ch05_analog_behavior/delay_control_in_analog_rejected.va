// §5.2: "no blocking event control statements (such as blocking delays,
// blocking events, or waits) are supported". `#5` is a blocking delay, and an
// analog block has no execution thread that could be suspended for it. The
// legal neighbour, analog_block.va, runs the same sequential assignments with
// the delay removed.
//
//! lrm 5.2
//! lrm 5.2:1001
//! reject-only E0254
//! neighbour analog_block.va
`include "disciplines.vams"
module ch5_analog_delay(p);
  inout p; electrical p; real x;
  analog begin
    #5 x = 1.0;
    I(p) <+ x * V(p);
  end
endmodule
