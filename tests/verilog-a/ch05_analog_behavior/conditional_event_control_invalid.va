// §5.8.4 "Restrictions on conditional statements", last sentence: "Event
// control statements (e.g.: timer, cross) cannot be used inside conditional
// statements unless the conditional expression is a constant expression."
//
// The cite is §5.8.4 and not its §5.8 parent, which is a two-bullet list of the
// kinds of conditional statement and states no rule at all; and not §5.10.3.1,
// whose version of the restriction is worded for cross() alone ("it shall not
// be used inside an if, case, casex, or casez statement unless the conditional
// expression is a genvar expression"). The event guarded below is
// @(initial_step), a §5.10.2 global event and not a cross(), so §5.8.4 is the
// only clause that reaches this file.
//
// `V(c) > 0.5` is not a constant expression: a probe comparison is re-evaluated
// at every Newton iteration, at operating points the detector never sees. Note
// this is STRICTER than §5.8.1's rule for analog operators, which
// conditional_filter_invalid.va pins — `if (analysis("dc"))` licenses a filter
// but still not an event.
//
// The guarded statement is a plain assignment, and event_cross_enable.va shows
// the legal way to write the same intent: the event on the spine of the block
// with the condition inside its body.
//
//! lrm 5.8.4
//! lrm 5.8.4:1000
//! reject-only E0707
//! neighbour event_cross_enable.va
`include "disciplines.vams"
module ch5_conditional_event_control(p, c);
  inout p, c; electrical p, c; real x;
  analog begin
    x = 0.0;
    if (V(c) > 0.5) @(initial_step) x = 1.0;
    I(p) <+ x;
  end
endmodule
