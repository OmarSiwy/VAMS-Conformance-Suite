// §5.10.3.1 on cross()'s optional arguments: "The dir and enable arguments, if
// specified, shall evaluate to integers."
//
// The clause then spends a paragraph on what each integer means — 0 or absent
// is both edges, +1 rising, -1 falling — and closes it with "for any other
// values of dir, the cross() function does not generate an event and does not
// act to control the timestep". That inert path is the one thing that could
// make this file an inversion, so read what it ranges over: dir has already
// been required to evaluate to an integer, so "any other values" enumerates the
// remaining INTEGERS (2, -7, …), not the reals. 0.5 is not one of them, and
// nothing in §5.10.3.1 puts a real in the direction slot and then rounds it —
// the sentence states a requirement ON THE ARGUMENT, while §4.2.1.2's
// real-to-integer conversion is written for assignment contexts, not for an
// operand the clause has already typed. A tool that quietly rounded 0.5 to +1
// would by the same rule have to read -0.4 as 0 and silently swap "falling" for
// "both edges", which is the ambiguity "shall evaluate to integers" exists to
// forbid. So the call is ill-formed rather than merely inert.
//
// The direction slot itself is exercised legally elsewhere and must keep
// compiling: event_cross.va passes +1, event_cross_falling.va -1 and
// event_cross_any.va 0 through this same position. The tolerance half of the
// same sentence is cross_tolerance_negative_invalid.va, and the requirement
// that a tolerance be accompanied by a direction is
// event_null_argument_invalid.va.
//
// VerA refuses it with E0517, the §5.10.3 event-argument code.
//
//! lrm 5.10.3.1
//! lrm 5.10.3.1:3
//! reject-only E0517
//! neighbour event_cross.va
//! neighbour event_cross_any.va
//! neighbour event_cross_falling.va
`include "disciplines.vams"
module ch5_cross_dir_noninteger(p);
  inout p; electrical p; real x;
  analog begin
    x = 0.0;
    @(cross(V(p) - 1.0, 0.5)) x = 1.0;
    I(p) <+ x;
  end
endmodule
