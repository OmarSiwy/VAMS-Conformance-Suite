// §5.10.2: "The user model cannot generate these events." / "These events
// cannot be redefined in a model." `initial_step` and `final_step` are global
// events the tool raises at the first and last point of an analysis; the only
// event a model may trigger is a named event it declared (§5.10.4). The
// trigger below names `initial_step`, so there is no user event for it to set
// and the module is refused. The legal neighbour triggers a declared named
// event from an analog event statement.
//
//! lrm 5.10.2
//! lrm 5.10.2:1002
//! reject-only E0235
//! neighbour ../../verilog-ams/ch05_analog_behavior/named_event_unsupported.va
`include "disciplines.vams"
module ch5_trigger_global(p);
  inout p; electrical p;
  analog begin
    @(initial_step) -> initial_step;
    I(p) <+ 0.0 * V(p);
  end
endmodule
