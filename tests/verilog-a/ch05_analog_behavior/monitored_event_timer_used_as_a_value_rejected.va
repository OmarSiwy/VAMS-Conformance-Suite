// §5.10.3 Monitored events:
//
//   "MONITORED EVENTS ARE DETECTED USING EVENT FUNCTIONS WITH THE @ OPERATOR.
//    The triggering of a monitored event is implicit due to change in signals,
//    simulation time, or other runtime conditions."
//
// and the grammar places all four of the clause's functions — cross, above,
// timer, absdelta — in `analog_event_functions`, which Syntax 5-13 reaches only
// through `analog_event_expression`, i.e. only inside `@( ... )`. An event
// "does not hold any data" (§5.10), so a monitored event function returns
// nothing an assignment could store.
//
// `cross_used_as_a_value_rejected.va` pins this for §5.10.3.1's cross(). This
// file pins it for §5.10.3.3's timer(), whose event depends on SIMULATION TIME
// rather than on a signal — the second of the clause's "change in signals,
// simulation time, or other runtime conditions" — so a check written only for
// the signal-driven functions would miss it.
//
// EXACTLY ONE RULE IS BROKEN: `@(timer(1n)) x = 1.0;` is the legal spelling
// (`event_timer.va`).
//
//! lrm 5.10.3
//! lrm 5.10.3.3
//! lrm 5.10.3:1000
//! reject-only E0701
//! neighbour event_timer.va
`include "disciplines.vams"
module ch5_timer_as_value(p);
  inout p; electrical p;
  real x;
  analog begin
    x = timer(1n);
    I(p) <+ x * V(p);
  end
endmodule
