// §5.10.3.3 controls changed before the timer condition. The host supplies
// start/period in units of the parameter and enable as a solved boolean.
`include "disciplines.vams"
module timer_controls(out, start_ctl, period_ctl, enable_ctl);
  inout out, start_ctl, period_ctl, enable_ctl;
  electrical out, start_ctl, period_ctl, enable_ctl;
  parameter real period = 2n;
  integer fires;
  analog begin
    @(timer(period * V(start_ctl), period * V(period_ctl), 1p, V(enable_ctl) > 0.5))
      fires = fires + 1;
    I(out) <+ fires;
    I(start_ctl) <+ 0;
    I(period_ctl) <+ 0;
    I(enable_ctl) <+ 0;
  end
endmodule
