// Annex G Table G.2 item 13: "@(final_step) without arguments should not have
// parenthesis" (5.10.2, Table 5-1). A.6.5 makes that mechanical: the analysis
// list inside the parentheses is non-empty, and the whole parenthesised group
// is optional, so `final_step()` derives from no production. Both legal forms
// are covered by ch05_analog_behavior/final_step.va (bare) and
// initial_final_analysis_lists.va (analysis list).
//
//! lrm G.1
//! lrm 5.10.2
//! lrm A.6.5
//! lrm 5.10.2:1000
//! reject-only E0220
//! neighbour final_step.va
//! neighbour initial_final_analysis_lists.va
`include "disciplines.vams"
module ch5_final_step_empty_parens(p, n);
  inout p, n; electrical p, n;
  real x;
  analog begin
    x = 1.0;
    @(final_step()) x = 0.0;
    I(p, n) <+ V(p, n) + 0.0 * x;
  end
endmodule
