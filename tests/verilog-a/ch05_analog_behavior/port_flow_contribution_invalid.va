// §5.4.3: "The port access function shall not be used on the left side of a
// contribution operator <+."
//
// `I(<p>)` MEASURES the flow into port p from outside the module; it does not
// name a branch, so there is nothing for a contribution to accumulate into.
// port_potential_invalid.va pins §5.4.3's other prohibition, `V(<p>)`, which is
// illegal on either side; this one is legal on the right and illegal only here,
// so port_flow_probe.va reads the same access function and must keep compiling.
//
//! lrm 5.4.3
//! lrm 5.4.3:1
//! reject-only E0407
//! neighbour port_flow_probe.va
`include "disciplines.vams"
module ch5_port_flow_contribution(p);
  inout p; electrical p;
  analog I(<p>) <+ 1m;
endmodule
