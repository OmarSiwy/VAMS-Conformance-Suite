// §4.5.15: "Analog operators shall not be used inside conditional (if, case,
// or ?:) statements unless the conditional expression controlling the
// statement consists of terms which can not change their value during the
// course of a simulation." §5.8.1 says the same.
//
// `mode` is a variable, like `td` in conditional_ddt_parameter_variable.va,
// but its value is computed from `V(d, s)`, a §4.4 probe of the solution. It
// changes whenever the bias crosses zero, so on the iterations where
// `mode < 0` the `ddt` is not evaluated and its history is lost: exactly what
// the clause forbids. This is the shape of a MOSFET model selecting the drain
// side of the channel charge by operating mode (BSIM2's `mode`). Reading the
// condition through a variable must not launder the dependence away.
//
//! lrm 4.5.15
//! lrm 4.5.15:1
//! lrm 5.8.1
//! lrm 5.6.5
//! lrm 5.6.5:3
//! lrm 5.8.1:1
//! reject-only E0514
//! neighbour conditional_ddt_parameter_variable.va
`include "disciplines.vams"
module ch05_conditional_ddt_bias_variable_invalid(d, s);
    inout d, s;
    electrical d, s;
    real vds, mode, q;
    analog begin
        vds = V(d, s);
        mode = vds / (abs(vds) + 1.0e-30);
        q = 1.0e-15 * vds;
        if (mode >= 0.0) I(d, s) <+ ddt(q);
        I(d, s) <+ vds / 1.0e3;
    end
endmodule
