// §5.3 Block statements:
//
//   "The block statements, also referred to as sequential blocks, are a means
//    of grouping procedural statements. ... THE BLOCK STATEMENTS ARE DELIMITED
//    BY THE KEYWORDS begin AND end."
//
// and §5.3.1's Syntax 5-2 spells the delimiting as the production itself:
//
//   analog_seq_block ::= begin [ : analog_block_identifier
//                        { analog_block_item_declaration } ] { analog_statement } end
//
// A `begin` with no matching `end` is therefore not a block at all: the
// statements after it have no point at which "the control shall pass out of the
// block after the last statement is executed", and the `endmodule` that follows
// lands where Syntax 5-2 wants either another analog_statement or the `end`.
//
// EXACTLY ONE RULE IS BROKEN. The contribution inside the block is legal, the
// module header and declarations are legal, and `sequential_block.va` is the
// same body with its `end` present, which compiles and asserts.
//
// The directives pin the phase and the token the parser stopped on: every
// diagnostic comes from the parser (ParseError), and it names `endmodule`, the
// keyword that arrived while the block was still open.
//
//! lrm 5.3
//! lrm 5.3.1
//! lrm 5.3.1:1000
//! reject ParseError
//! reject endmodule
//! neighbour sequential_block.va
`include "disciplines.vams"
module ch5_block_missing_end(p);
  inout p; electrical p;
  analog begin
    I(p) <+ V(p);
endmodule
