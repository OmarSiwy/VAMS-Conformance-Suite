// §5.4.2.1: "If no value is specified for either the potential or the flow, the
// branch is a probe... Using both the potential and the flow of a probe branch
// is illegal."
//
// The unnamed branch (a,b) is never contributed to, so it is a probe. §5.4.2.1
// then fixes ONE of its two quantities at zero — "the branch potential of a flow
// probe is zero, the branch flow of a potential probe is zero" — and which one
// is decided by which the module reads. Reading both asks for two zeros at once
// and there is no branch that satisfies it.
//
// The contrast is source_probe_both.va: that branch IS contributed to, so
// §5.4.2.2's "both the potential and the flow of a source branch are accessible"
// applies and reading both is legal. potential_probe.va and flow_probe.va read
// one each. This file differs from all three only in reading both of a branch
// that has no source.
//
// E0423 ("both quantities of a probe branch are read") is VerA's code for this
// rule, and it replaces the phase label pinned before the code existed.
//
//! lrm 5.4.2.1
//! lrm 5.4.2.1:1
//! reject-only E0423
//! neighbour flow_probe.va
//! neighbour potential_probe.va
//! neighbour source_probe_both.va
`include "disciplines.vams"
module ch5_probe_both_quantities(a, b);
  inout a, b; electrical a, b;
  analog I(a) <+ V(a, b) + I(a, b);
endmodule
