// §5.2: "no blocking event control statements (such as blocking delays,
// blocking events, or waits) are supported". `wait (V(p) > 1.0)` blocks on a
// level in the statement stream, which an analog block does not have; the
// legal neighbour is the same module without the wait.
//
//! lrm 5.2
//! lrm 5.2:1001
//! reject-only E0255
//! neighbour analog_block.va
`include "disciplines.vams"
module ch5_analog_wait(p);
  inout p; electrical p; real x;
  analog begin
    x = 0.0;
    wait (V(p) > 1.0) x = 1.0;
    I(p) <+ x * V(p);
  end
endmodule
