// §5.10.3.1: "If expr_tol is specified, time_tol shall also be specified".
// The direction and expr_tol are valid; only time_tol is absent. Syntax 5-16
// permits the empty slot, so the named event-argument diagnostic must explain
// the semantic dependency. event_bounds_cross_legal.va supplies both tolerances
// and also runs the legal form that omits both of them.
//! lrm 5.10.3.1
//! lrm 5.10.3.1:6
//! reject-only E0517
//! neighbour event_bounds_cross_legal.va
`include "disciplines.vams"
module event_bounds_cross_missing_time(p);
  inout p; electrical p;
  integer n;
  analog begin
    @(cross(V(p), 1, , 1m)) n = n + 1;
    I(p) <+ 0.0;
  end
endmodule
