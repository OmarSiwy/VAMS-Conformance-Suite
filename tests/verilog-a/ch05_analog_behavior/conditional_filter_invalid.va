// §5.8.1 an analog operator under a condition that is not an
// analysis_or_constant_expression. If this fixture ever COMPILES again, the
// operator is back to being fed 0 on every step its branch was off.
//! lrm 5.8.1
//! lrm 5.6.1
//! lrm 5.6.1:3
//! lrm 5.6.5
//! lrm 5.6.5:3
//! lrm 5.8.1:1
//! lrm 5.8.4
//! lrm 5.8.4:1000
//! reject-only E0514
//! neighbour conditional_ddt_contribution_static.va
// §5.8.1: "If any of the conditionally-executed statements contains an analog
// operator, the conditional expression shall be a analysis_or_constant_
// expression." `V(c) > 0.0` is neither — a probe moves on every Newton
// iteration — so this module is illegal and E0514 rejects it.
//
// The rule is worth enforcing because the failure is invisible otherwise: an
// analog operator is a state machine the kernel advances once per accepted
// step, so the step on which this branch is off feeds `laplace_nd` the type's
// zero instead of the real input, and its history is wrong from then on. The
// residual keeps looking ordinary.
//
// The two carve-outs §5.8.1 does grant — `analysis()` and a `parameter` — are
// pinned in lower.zig's "§5.8.1 an analog operator under a runtime condition"
// test, which walks six conditions past the same operator.
`include "disciplines.vams"
module ch5_conditional_filter(p, c);
  inout p, c; electrical p, c;
  analog if (V(c) > 0.0)
    I(p) <+ laplace_nd(V(p), '{1.0}, '{1.0, 1.0});
endmodule
