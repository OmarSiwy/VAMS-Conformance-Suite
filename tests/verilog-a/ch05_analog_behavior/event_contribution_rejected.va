// §5.10 "Contribution statements cannot be used inside an event control block
// because it can generate discontinuity in analog signals." A.6.4's
// `analog_event_statement` correspondingly has no contribution_statement
// alternative.
//
// The event here is a monitored cross() event, which VerA supports, so the
// contribution really is the first thing wrong with the file — nothing else in
// it is unimplemented, and the diagnostic cannot be reached by accident.
//
//! lrm 5.10
//! lrm 5.6.5
//! lrm 5.6.5:2
//! lrm 5.6.5:4
//! lrm 5.10:2
//! reject-only E0406
//! neighbour conditional_contribution.va
`include "disciplines.vams"
module ch5_event_contribution_rejected(p);
  inout p; electrical p;
  analog begin
    I(p) <+ 0.0;
    @(cross(V(p) - 1.0, +1)) I(p) <+ 1m;
  end
endmodule
