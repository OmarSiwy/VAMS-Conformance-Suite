// LRM 5.4.3: "The expression V(<a>) is invalid for ports and nets, where V is a
// potential access function."  A port access function reads the FLOW into the
// port and nothing else.  (§4.4.2 gives the access function grammar; §5.4.3 is
// where the prohibition itself is stated, so that is what is cited.)
//! lrm 5.4.3
//! lrm 5.5.1
//! lrm 5.5.1:4
//! reject-only E0507
//! reject potential access function
//! lrm 5.4.3:1001
//! neighbour port_access_hierarchical_instance.va
`include "disciplines.vams"
module ch5_bad_port_potential(p);
  inout p; electrical p;
  analog I(p) <+ V(<p>);
endmodule
