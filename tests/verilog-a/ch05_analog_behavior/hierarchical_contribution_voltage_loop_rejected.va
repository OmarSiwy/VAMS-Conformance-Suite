// §5.6.8.1 Contributions to branches between hierarchical nets:
//
//   "Direct contribution statements can contribute to a branch between
//    combinations of local and hierarchical nets. In these cases, a new unnamed
//    branch is created in the module containing the direct contribution
//    statements. ...
//    THE SIMULATOR SHALL CHECK IF THE CONTRIBUTION PRODUCES A SOLVABLE SET OF
//    EQUATIONS, E.G. NO VOLTAGE SOURCE LOOPS CREATED."
//
// The child owns a 1.0 V potential source from its internal net x to ground.
// The parent writes `V(drv.x) <+ 1.8;` — the clause's own first example — and by
// the sentence above that creates a SECOND unnamed branch, in the parent, from
// drv.x to ground. Two potential sources now sit in parallel between the same
// two nodes: a voltage source loop. Kirchhoff's voltage law around it demands
// V(x) = 1.0 and V(x) = 1.8 at once, and even if the two values agreed the
// currents through the two sources would be undetermined (only their sum is
// fixed). No operating point exists, so this is exactly the unsolvable set of
// equations the simulator "shall check" for.
//
// WHY THE LEGAL NEIGHBOURS STAY LEGAL.
//   - `hierarchical_contribution_creates_a_new_branch.va`: the parent's
//     new potential branch runs x-to-y, parallel to a CONDUCTANCE, not to a
//     source — no loop, and it solves.
//   - `hierarchical_named_branch_accumulates.va`: a hierarchical
//     potential contribution to the child's OWN named branch accumulates into
//     it (§5.6.8.2) — one branch, one source, no loop.
//   - A loop whose sources are all written in ONE module is not this rule's
//     subject (its author can see it); `hierarchical_contribution_unsupported.va`
//     transcribes the clause's example, whose four contributions all sit in the
//     parent, and keeps compiling.
//
// WHAT USED TO HAPPEN: accepted silently, and the device stamped two rows that
// both claimed node x. E0477 now names the parent's contribution as the one that
// closes a loop with the child's.
//
// EXACTLY ONE RULE IS BROKEN: change the parent's line to a flow contribution
// (`I(drv.x) <+ 1m;`) and the design is a current source into a pinned node.
//
//! lrm 5.6.8.1
//! lrm 5.6.8
//! lrm 5.6.8.1:1
//! reject-only E0477
//! reject closes a loop of potential sources
//! neighbour hierarchical_contribution_creates_a_new_branch.va
//! neighbour hierarchical_named_branch_accumulates.va
//! neighbour hierarchical_contribution_unsupported.va
`include "disciplines.vams"
module ch5_hier_vloop(g);
  inout g;
  electrical g;
  ch5_hier_vloop_child drv(g);
  analog begin
    V(drv.x) <+ 1.8;
    I(g) <+ 0.0;
  end
endmodule

module ch5_hier_vloop_child(t);
  inout t;
  electrical t, x;
  analog begin
    V(x) <+ 1.0;
    I(t) <+ 0.0;
  end
endmodule
