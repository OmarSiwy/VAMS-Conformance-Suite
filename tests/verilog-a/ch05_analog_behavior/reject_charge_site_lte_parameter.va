// VerA's `vera_lte` attribute (§2.9) with a value the model card decides.
//
// §2.9: `attr_spec ::= attr_name [ = constant_expression ]`. A parameter IS a
// constant expression, but VerA's answer is a compile-time table (`q_lte`,
// one bool per charge site, `contract.QStamp`) that exists before any model
// card does, so the value must fold without one. E0523 names that.
//! lrm 2.9
//! reject-only E0523
`include "disciplines.vams"
module reject_charge_site_lte_parameter(p, n);
  inout p, n; electrical p, n;
  parameter integer check = 0;
  analog begin
    (* vera_lte = check *) I(p, n) <+ ddt(1e-12 * V(p, n));
  end
endmodule
