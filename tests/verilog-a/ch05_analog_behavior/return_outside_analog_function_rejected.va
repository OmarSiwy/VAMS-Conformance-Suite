// §5.11: "The return statement can only be used from within an analog
// user-defined function." A `return;` on the analog block's spine has no
// function to return from. The legal neighbour returns from two analog
// user-defined functions, one per numeric return type.
//
//! lrm 5.11
//! lrm 5.11:1004
//! reject-only E0403
//! neighbour return_expression_of_the_function_type.va
`include "disciplines.vams"
module ch5_return_outside_function(p);
  inout p; electrical p;
  analog begin
    return;
    I(p) <+ V(p);
  end
endmodule
