// §5.3.2 Block names: "All identifiers declared within a named sequential
// block can be accessed outside the scope in which they are declared. Named
// block variables cannot be assigned outside the scope of the block in which
// they are declared."
//
// This is the clause's own example (a03_06, which reads `myscope.localVar`
// from the spine and must keep compiling) with one statement added: the same
// hierarchical name as an assignment TARGET, outside `myscope`. Reading it is
// the first sentence; writing it is the second, and only the write is
// refused. The pair therefore shows a restriction on the direction of access,
// not a refusal of hierarchical block names.
//
// VerA's diagnostic is E0316, whose message for a hierarchical target is "a
// hierarchical name is not an assignment target" (§5.7's third restriction,
// "Hierarchical assignment of a variable from another scope/module is not
// allowed", is the same rule seen from the assignment).
//
//! lrm 5.3.2
//! lrm 5.3.2:1000
//! reject-only E0316
//! neighbour named_block_local_by_hierarchical_name.va
//! lrm 5.3.2:1003
`include "disciplines.vams"
module b3_named_block_local_assigned_from_outside(p);
  inout p; electrical p;
  parameter integer p1 = 1;
  real moduleVar;
  analog begin
    begin : myscope
      parameter real p2 = p1;
      real localVar = 1.5 * p2;
    end
    myscope.localVar = 2.0;          // illegal: assigned outside `myscope`
    moduleVar = myscope.localVar;    // legal: read outside `myscope`
    I(p) <+ 0.0;
  end
endmodule
