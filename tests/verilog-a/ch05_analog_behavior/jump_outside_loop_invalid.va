// §5.11: "The continue and break statements can only be used in a loop."
//
// jump_break.va and jump_continue.va assert the positive semantics inside a
// §5.9.2 for statement; there is no loop at all here, so the statement has no
// target to jump to and the module is illegal.
//
//! lrm 5.11
//! reject-only E0404
//! neighbour jump_break.va
//! neighbour jump_continue.va
//! lrm 5.11:1001
`include "disciplines.vams"
module ch5_jump_outside_loop(p);
  inout p; electrical p;
  analog begin
    break;
    I(p) <+ 0.0;
  end
endmodule
