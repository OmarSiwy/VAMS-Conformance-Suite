// §5.10.3.1 cross(), the argument-dependency rule:
//
//   "If the tolerances are not specified, then the tool (e.g., the simulator)
//    sets them. IF EITHER OR BOTH TOLERANCES ARE DEFINED, THEN THE DIRECTION
//    SHALL ALSO BE DEFINED."
//
// "Shall" with no stated outcome for violating it makes this a source rule, so
// the diagnosis belongs at compile time. The construct below is legal GRAMMAR —
// A.6.5 spells the second argument `analog_expression_or_null`, so the empty
// slot parses — and it is the clause, not the syntax, that rules it out.
//
// WHY THE RULE EXISTS, which is also why silently defaulting is not an
// acceptable reading: with no direction the event fires on BOTH edges, and a
// time_tol that was written for one edge of a slow ramp is then applied to the
// opposite edge of a fast one. §5.10.3.1's next paragraph is explicit that the
// two tolerances are what the event is resolved against, so the pairing is
// load-bearing and not stylistic.
//
// The companion rule in the same paragraph — "If expr_tol is specified, time_tol
// shall also be specified" — is pinned separately by
// event_bounds_cross_expr_tol_without_time_tol_rejected.va. Clause coverage
// alone does not establish that both independent prohibitions are enforced.
//
// A reject, so there is nothing to run and no `want` to write. The substring is
// the word the diagnostic has to contain for a reader to know which of cross()'s
// five arguments is at fault.
//
// THIS ONE ALREADY HOLDS. VerA refuses it today with
//
//   error[E0517]: cross()/above() argument is the wrong type or out of range:
//     a tolerance is given but the direction slot is empty
//
// so this file is a pin and not a gap: it is here because nothing in
// tests/fixtures cited §5.10.3.1 for this rule, and an unpinned refusal is one
// refactor away from being an accepted default.
//
//! lrm 5.10.3.1
//! lrm 5.10.3.1:4
//! reject-only direction
`include "disciplines.vams"
module a10_cross_tol_without_dir(p);
  inout p;
  electrical p;
  integer n;
  analog begin
    @(cross(V(p) - 1.0, , 1n)) n = n + 1;
    I(p) <+ 0.0;
  end
endmodule
