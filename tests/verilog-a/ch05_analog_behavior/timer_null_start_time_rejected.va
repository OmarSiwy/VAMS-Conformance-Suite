// §5.10.3.3, under Syntax 5-18: "timer ( start_time [ , period [ , time_tol
// [ , enable ] ] ] ) where start_time is required; period, time_tol and enable
// are optional arguments." The syntax's first slot is `analog_expression`, the
// next two `analog_expression_or_null`.
//
// event_timer.va's `timer(0.0, 1n, 1p)` with the start_time left null: a null
// where the grammar admits none, whichever way §5.10's "Null arguments are not
// allowed in analog events" is read. start_time is the absolute time the
// clause says the event "occurs at", and reading a null one as 0.0 would
// invent it. event_timer.va must keep compiling.
//
// (The empty call `timer()` is the same rule; it crashes this compiler, see
// the b3 bug list, so it is not a fixture until that is fixed.)
//
// The expected refusal is the §5.10.3 event-argument code, E0517.
//
//! lrm 5.10.3.3
//! lrm 5.10.3.3:1
//! reject-only E0517
//! neighbour event_timer.va
//! lrm 5.10:1
`include "disciplines.vams"
module b3_timer_null_start_time(p);
  inout p; electrical p; real state;
  analog begin
    @(timer(, 1n, 1p)) state = 1.0 - state;   // illegal: start_time is required
    V(p) <+ transition(state, 0.0, 1p, 2p);
  end
endmodule
