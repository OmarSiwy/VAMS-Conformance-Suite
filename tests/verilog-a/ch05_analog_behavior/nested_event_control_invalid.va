// §5.10, third bullet of the list of restrictions on statements inside an event
// control block: "Nested event control statements are not allowed." (Not the
// list of event CHARACTERISTICS higher up the clause, which says nothing about
// nesting.) A.6.4 makes the same point structurally: an analog_event_statement's
// body is a plain analog_statement, so it cannot itself be another event
// control statement. The LRM's remedy is the
// `or` combinator — `@(initial_step or final_step)` — which event_or.va and
// event_initial_or_cross.va cover on the positive side.
//
// Both events named here are global (§5.10.2) and both are implemented, so the
// nesting is the only thing wrong with the file.
//
//! lrm 5.10
//! lrm 5.10:2
//! reject-only E0703
//! neighbour event_initial_or_cross.va
//! neighbour event_or.va
`include "disciplines.vams"
module ch5_nested_event_control(p);
  inout p; electrical p; real x;
  analog begin
    @(initial_step) @(final_step) x = 1.0;
    I(p) <+ x;
  end
endmodule
