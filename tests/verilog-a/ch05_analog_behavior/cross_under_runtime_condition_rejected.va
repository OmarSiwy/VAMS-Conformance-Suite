// §5.10.3.1: "The cross() function maintains its internal state and has the
// same restrictions as analog operators. In particular, it shall not be used
// inside an if, case, casex, or casez statement unless the conditional
// expression is a genvar expression."
//
// cross_under_genvar_condition.va with the condition `k == 1` replaced by
// `V(p) > 0.0`, a probe comparison: it is not a genvar expression, and it can
// change from one Newton iteration to the next, so the detector would be
// sampled at some solutions and not others and its internal state would have
// no consistent history. The genvar loop around it is unchanged, so the only
// difference between the pair is the kind of condition.
//
// VerA refuses it with E0707, "event control statement under a runtime
// condition or in a loop" (once per unrolled copy).
//
//! lrm 5.10.3.1
//! lrm 5.10.3.1:7
//! reject-only E0707
//! neighbour cross_under_genvar_condition.va
`include "disciplines.vams"
module b3_cross_under_runtime_condition(p);
  inout p; electrical p;
  genvar k;
  integer n;
  analog begin
    for (k = 0; k < 2; k = k + 1)
      if (V(p) > 0.0) @(cross(V(p), 1)) n = n + 1;   // illegal: not a genvar condition
    I(p) <+ 0.0;
  end
endmodule
