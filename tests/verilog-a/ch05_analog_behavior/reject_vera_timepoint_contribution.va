// VerA's `vera_timepoint` attribute (§2.9) over a contribution statement.
//
// A cached statement does not run on the later iterations of a timepoint, so
// a §5.6 contribution inside one would leave its branch with no residual and
// no Jacobian there. E0530 names it. The legal neighbour computes the value
// inside the statement and contributes it outside, as
// vera_timepoint_cache.va does.
//! lrm 2.9
//! reject-only a contribution (§5.6)
//! neighbour vera_timepoint_cache.va
`include "disciplines.vams"
module reject_vera_timepoint_contribution(p, n);
  inout p, n; electrical p, n;
  analog begin
    (* vera_timepoint *) I(p, n) <+ 1u * $abstime;
    I(p, n) <+ V(p, n) / 1k;
  end
endmodule
