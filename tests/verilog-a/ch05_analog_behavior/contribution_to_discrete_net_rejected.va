// §5.4 Analog signals:
//
//   "Analog signals are distinguished from digital signals in that AN ANALOG
//    SIGNAL HAS A DISCIPLINE WITH A CONTINUOUS DOMAIN."
//
// §5.6 Contribution statements:
//
//   "The branch contribution statement is used in the analog block to describe
//    continuous-time behavior between a module's ANALOG NETS and ports."
//
// and §5.6.1 states the consequence as a rule:
//
//   "There shall be no contributions to an implicit net; CONTRIBUTIONS SHALL BE
//    DONE ONLY ON ANALOG NETS DECLARED WITH A CONTINUOUS DISCIPLINE."
//
// `d` is declared with Annex D.1's `logic` discipline, `domain discrete`, which
// binds no nature at all. It is a digital signal, so there is no potential for
// `V(d)` to name and nothing for a contribution to assign: the left-hand side
// "shall consist of a signal access function applied to a branch" (§5.6.1), and
// no branch of continuous discipline exists between `d` and ground.
//
// The read-side twin is `reject_5_5_1_probe_of_discrete_net.va` (probing a
// discrete net). This file is the WRITE side, which is the one §5.6.1 states as
// a "shall": a compiler that let the contribution through would be stamping a
// residual row for a node the analog solver does not own.
//
// EXACTLY ONE RULE IS BROKEN: `I(p) <+ V(p)` is a legal 1-ohm load on an
// electrical port, and `d` itself is a legal discrete port.
//
//! lrm 5.4
//! lrm 5.6
//! lrm 5.6.1
//! lrm 5.6.1:5
//! reject-only E0501
//! reject `V` is not an access function of `d`
//! neighbour analog_signals_nets_branches_contributions.va
`include "disciplines.vams"
module ch5_contribution_to_discrete(p, d);
  inout p; electrical p;
  inout d; logic d;
  analog begin
    V(d) <+ 1.0;
    I(p) <+ V(p);
  end
endmodule
