// §5.4.1 Access functions:
//
//   "Flows and potentials on nets, ports, and branches are accessed using
//    access functions. THE NAME OF THE ACCESS FUNCTION IS TAKEN FROM THE
//    DISCIPLINE OF THE NET, PORT, OR BRANCH associated with the signal."
//
// and the clause's Example 1 spells out the only two names an electrical branch
// has: "electrical is a discipline with V as the access function for the
// potential and I as the access function for the flow. The potential (voltage)
// is accessed via V(b) and the flow (current) is accessed via I(b)."
//
// Below, `b` is a NAMED electrical branch and it is read through `Temp`, the
// access function Annex D.1 binds to the `Temperature` nature of the THERMAL
// discipline. `Temp` is a perfectly good access function name in this design —
// disciplines.vams declares it — it is just not one the discipline of `b`
// supplies, so the name cannot be "taken from the discipline of the branch".
//
// This is the branch-name half of the rule. The annex D fixtures
// (`unbound_nature_access_rejected.va`) pin the same refusal on a bare net;
// what this file adds is that naming a branch does not open a path around the
// discipline check — the branch inherits its discipline from its two electrical
// terminals (§3.6), and the check is made against that.
//
// EXACTLY ONE RULE IS BROKEN: replace `Temp(b)` with `V(b)` and the module is
// the §5.6.3 conductor, which `conductor.va` runs.
//
//! lrm 5.4.1
//! lrm 5.4.1:1000
//! lrm 5.5.1
//! lrm 5.5.1:3
//! reject-only E0501
//! reject Temp
//! neighbour conductor.va
//! lrm 5.5.1:1001
`include "disciplines.vams"
module ch5_access_not_of_discipline(p, n);
  inout p, n;
  electrical p, n;
  branch (p, n) b;
  analog I(b) <+ 1.0e-3 * Temp(b);
endmodule
