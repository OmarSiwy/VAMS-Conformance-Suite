// §5.8.3: "The default statement is optional. Use of multiple default
// statements in one case statement is illegal."
//
// Two default arms leave the fall-through arm ambiguous — nothing in §5.8.3
// orders them — so the rule is a well-formedness rule, not a preference.
// case_default_only.va and case_statement.va are the legal forms and must keep
// compiling; the only difference here is the second `default:`.
//
// E0427 ("more than one `default` arm in a case statement") is VerA's code for
// this rule, and it replaces the phase label pinned before the code existed.
//
//! lrm 5.8.3
//! lrm 5.8.3:2
//! reject-only E0427
//! neighbour case_default_only.va
//! neighbour case_statement.va
`include "disciplines.vams"
module ch5_case_duplicate_default(p);
  inout p; electrical p; integer s; real x;
  analog begin
    s = 1;
    case (s)
      0:       x = 1.0;
      default: x = 2.0;
      default: x = 3.0;
    endcase
    I(p) <+ x;
  end
endmodule
