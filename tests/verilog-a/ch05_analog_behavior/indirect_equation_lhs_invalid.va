// §5.6.7 and Syntax 5-7: the left side of the `==` in an indirect contribution
// names the QUANTITY that is driven to the right-hand value, so it must be a
// branch access function, or ddt/idt/idtmod applied to one. A plain variable
// names no quantity in the equation system and there is nothing for the solver
// to drive.
//
// The target of the `:` here is well formed (`V(p)`), and the same statement
// with `I(p)` in place of `x` is the legal opamp form of §5.6.7, so the `==`
// left side is the only defect.
//
//! lrm 5.6.7
//! lrm 5.6.7:1
//! reject-only E0414
//! neighbour indirect_contribution.va
`include "disciplines.vams"
module ch5_indirect_equation_lhs(p, c);
  inout p, c; electrical p, c; real x;
  analog begin
    x = 1.0;
    V(p) : x == 0.0;
    I(c) <+ 0.0;
  end
endmodule
