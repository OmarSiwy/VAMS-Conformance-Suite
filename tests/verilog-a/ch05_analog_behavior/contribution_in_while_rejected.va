// §5.9 Looping statements, the restrictions that apply to `repeat`, `while` and
// a non-genvar `for` — i.e. to both statements §5.9.1 defines:
//
//   "The following restrictions are applied to looping statements (repeat,
//    while and for) except for analog_for statements, refer 5.9.3
//      — Analog filter functions are not allowed
//      — Event control statements are not allowed
//      — CONTRIBUTION STATEMENTS ARE NOT ALLOWED"
//
// §5.9.1 Repeat and while statements: "while() executes a statement until an
// expression becomes False. If the expression starts out False, the statement
// is not executed at all." The number of times the body runs is data, decided
// at run time — which is exactly why its body may not contribute: the set of
// branches a device stamps (and so the size of the system) would then depend on
// a value the solve is still computing.
//
// `loop_contribution_invalid.va` pins the rule on a `for`;
// `contribution_in_repeat_rejected.va` on a `repeat`. This file pins it on
// §5.9.1's `while`, whose body `while_loop.va` shows is otherwise legal: the
// same loop with the contribution moved after it compiles and asserts.
//
// EXACTLY ONE RULE IS BROKEN: move `I(p) <+ 1.0e-3;` out of the loop body.
//
//! lrm 5.9.1
//! lrm 5.9
//! lrm 5.9:1
//! reject-only E0426
//! neighbour while_loop.va
`include "disciplines.vams"
module ch5_while_contribution(p);
  inout p; electrical p;
  integer i;
  analog begin
    i = 0;
    while (i < 2) begin
      I(p) <+ 1.0e-3;
      i = i + 1;
    end
  end
endmodule
