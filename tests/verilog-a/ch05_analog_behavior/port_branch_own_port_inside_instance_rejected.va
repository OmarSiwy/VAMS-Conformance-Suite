// A VerA limit, not an LRM rule (specification/Vague_Decisions.md §7, E0997): the
// port-branch spelling of port_access_own_port_inside_instance_rejected.va.
// §3.12.1: "A port branch is a special type of branch used to access the
// flow into a port of a module (see 5.4.3). It is a branch between the upper
// and lower connections of the port." So `I(pb)` over `branch (<a>) pb;` names
// the same quantity as `I(<a>)`. Read inside an instance, that is
// the flow into the instance's own port, which VerA has only as a sum read
// from above it; the read is refused by name rather than answered with the
// joined net's (the top's) port flow, as it was until 2026-10-08.
//
// port_access_hierarchical_instance.va is the legal neighbour: the leaves'
// port flows read from the top as `I(<u1.a>)`, `I(<u2.a>)`.
//
//! lrm 5.4.3
//! reject-only E0997
//! neighbour port_access_hierarchical_instance.va
`include "disciplines.vams"
module pbop_g(a);
  inout a; electrical a;
  parameter real r = 1k;
  branch (<a>) pb;
  real seen;
  analog begin
    I(a) <+ V(a) / r;
    seen = I(pb);
  end
endmodule
module pbop_top(p);
  inout p; electrical p;
  pbop_g #(.r(2k)) u1(p);
  pbop_g #(.r(1k)) u2(p);
endmodule
