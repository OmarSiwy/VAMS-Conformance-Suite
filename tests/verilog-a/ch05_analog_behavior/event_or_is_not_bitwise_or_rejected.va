// §5.10.1 Event OR operator:
//
//   "The 'OR-ing' of events indicates the occurrence of any one of the events
//    specified shall trigger the execution of the procedural statement following
//    the event. THE KEYWORD or IS USED AS AN EVENT OR OPERATOR. A comma ( , ) can
//    be used interchangeably with the keyword or to OR event expressions."
//
// Syntax 5-13 has exactly those two joiners and no third:
//
//   analog_event_expression ::= ...
//       | analog_event_expression or analog_event_expression
//       | analog_event_expression , analog_event_expression
//
// `initial_step` and `final_step` are GLOBAL EVENTS (§5.10.2), alternatives of
// analog_event_expression — they are not `expression`s, so they have no value
// a bitwise `|` could combine, and `initial_step | final_step` matches neither
// the `expression` alternative nor either joining production. The C habit of
// spelling "or" as `|` is therefore a syntax error here, not a synonym.
//
// `initial_final_analysis_lists.va` and `event_or.va` exercise the legal
// joiners; this file is the same event list joined with the one operator the
// clause does not name.
//
// EXACTLY ONE RULE IS BROKEN: write `or` (or `,`) for `|` and the statement is
// legal. The directives pin the phase and the offending token.
//
//! lrm 5.10.1
//! reject-only ParseError
//! reject `|`
//! neighbour event_or.va
//! neighbour initial_final_analysis_lists.va
`include "disciplines.vams"
module ch5_event_bitwise_or(p);
  inout p; electrical p;
  real x;
  analog begin
    @(initial_step | final_step) x = 1.0;
    I(p) <+ V(p);
  end
endmodule
