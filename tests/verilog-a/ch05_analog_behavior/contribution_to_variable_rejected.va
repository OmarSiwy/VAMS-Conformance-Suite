// §5.6.1: "It shall consist of a signal access function applied to a branch."
// A contribution's left side is a branch, never a variable, so `x <+ 1.0`
// derives from no production; a variable takes `=` (§5.7). The legal
// neighbour uses both forms where they belong, on branch access functions.
//
//! lrm 5.6.1
//! lrm 5.6.1:2
//! reject-only E0408
//! neighbour analog_signals_nets_branches_contributions.va
`include "disciplines.vams"
module ch5_contribution_to_variable(p);
  inout p; electrical p; real x;
  analog begin
    x <+ 1.0;
    I(p) <+ V(p);
  end
endmodule
