// §5.10.3.1, under Syntax 5-16: "cross ( expr [ , dir [ , time_tol [ ,
// expr_tol [ , enable ] ] ] ] ) where expr is required, and dir, time_tol,
// expr_tol, and enable are optional."
//
// The syntax draws the same line: the first slot of `cross (` is
// `analog_expression`, the four after it `analog_expression_or_null` (or
// optional). So `cross(, 1)` keeps the direction and leaves expr null: a null
// where the grammar admits none, whichever way §5.10's "Null arguments are not
// allowed in analog events" is read (the readers' open doubt is about the
// optional slots only). There is nothing whose zero crossing is to be
// detected. event_bounds_cross_legal.va calls cross() with its expr and every
// legal arrangement of the optional slots, and must keep compiling.
//
// (The empty call `cross()` is the same rule; it crashes this compiler, see
// the b3 bug list, so it is not a fixture until that is fixed.)
//
// The expected refusal is the §5.10.3 event-argument code, E0517.
//
//! lrm 5.10.3.1
//! lrm 5.10.3.1:1
//! reject-only E0517
//! neighbour event_bounds_cross_legal.va
//! lrm 5.10:1
`include "disciplines.vams"
module b3_cross_null_expr(p);
  inout p; electrical p;
  integer n;
  analog begin
    @(cross(, 1)) n = n + 1;           // illegal: expr is required
    I(p) <+ 0.0;
  end
endmodule
