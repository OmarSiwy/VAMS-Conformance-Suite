// §5.11: "The continue and break statements cannot be used inside an analog
// for loop. Refer 5.9.3."
//
// The jump here is inside an analog_for that is itself inside a runtime
// `while`. The nearest enclosing loop is the analog_for, so the sentence
// applies; a compiler that looks only for "some enclosing runtime loop"
// would accept it and make the `continue` jump to the while's test, a loop
// the author did not name. The diagnostic is E0440, not E0404: the
// statement is inside a loop, the wrong kind.
//
//! lrm 5.11
//! lrm 5.9.3
//! reject-only E0440
//! neighbour jump_in_runtime_for_in_analog_for.va
`include "disciplines.vams"
module ch5_jump_in_analog_for_inside_while(p);
  inout p; electrical p; genvar k; integer n; real x;
  analog begin
    x = 0.0; n = 0;
    while (n < 2) begin
      n = n + 1;
      for (k = 0; k < 3; k = k + 1) begin
        if (k == 1) continue;
        x = x + 1.0;
      end
    end
    I(p) <+ x;
  end
endmodule
