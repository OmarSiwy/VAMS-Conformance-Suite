// §5.4.2.2 Sources:
//
//   "A branch, either named or unnamed, is a source branch if either the
//    potential or the flow of that branch is assigned a value by a contribution
//    statement (see 5.6) anywhere in the module. It is a potential source if the
//    branch potential is specified and is a flow source if the branch flow is
//    specified. A BRANCH CANNOT SIMULTANEOUSLY BE BOTH A POTENTIAL AND A FLOW
//    SOURCE, although it can switch between them (a switch branch)."
//
// The switching half is legal and pinned elsewhere (`switch_branch.va`,
// `value_retention.va`): two DIRECT contributions of opposite kinds are resolved
// per iteration by §5.6.1.3, the later one discarding the earlier, so the branch
// is only ever one kind at a time and no source text written with `<+` alone can
// make it both.
//
// An INDIRECT contribution can. §5.6.7's `I(p,n) : V(c) == 0.5` makes (p,n) a
// FLOW source whose value the solver adjusts on every iteration of every point —
// it is not a retained value §5.6.1.3 can discard, it is an equation. Adding
// `V(p,n) <+ 1.0` to the same pair would then make (p,n) a potential source in
// the same iteration while the equation still owns its flow: both at once. That
// is exactly why §5.6.7.2 states the rule from the indirect side — "Indirect
// contribution statements is incompatible with direct contribution statements
// across the same pair of analog nets ... Once a value is indirectly assigned to
// a branch, it cannot be contributed to using the branch contribution operator
// <+."
//
// `indirect_and_direct.va` pins the POTENTIAL-indirect / FLOW-direct direction.
// This file is its mirror: flow indirectly, potential directly. A check keyed on
// the access function of the indirect target (rather than on the node pair)
// would pass one and miss the other, which is why both are pinned.
//
// EXACTLY ONE RULE IS BROKEN: delete the `V(p,n) <+ 1.0;` line and the module
// is a legal nullor-driven current source into (p,n).
//
//! lrm 5.4.2.2
//! lrm 5.4.2
//! lrm 5.6.7.2
//! lrm 5.6.7.2:1000
//! reject-only E0409
//! reject indirectly assigned
//! neighbour switch_branch.va
//! neighbour value_retention.va
`include "disciplines.vams"
module ch5_source_both_kinds(p, n, c);
  inout p, n, c;
  electrical p, n, c;
  analog begin
    I(p, n) : V(c) == 0.5;
    V(p, n) <+ 1.0;
    I(c) <+ V(c);
  end
endmodule
