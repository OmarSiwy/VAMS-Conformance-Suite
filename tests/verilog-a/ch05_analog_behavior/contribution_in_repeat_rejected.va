// §5.9 Looping statements:
//
//   "The following restrictions are applied to looping statements (repeat,
//    while and for) except for analog_for statements, refer 5.9.3
//      — Analog filter functions are not allowed
//      — Event control statements are not allowed
//      — CONTRIBUTION STATEMENTS ARE NOT ALLOWED"
//
// §5.9.1 Repeat and while statements: "repeat() executes a statement a fixed
// number of times. Evaluation of the expression decides how many times a
// statement is executed." The count is an `analog_expression` (Syntax 5-10),
// not a genvar expression, so even a count that happens to be the literal 2
// does not make this the §5.9.3 analog_for — the exemption is for the analog_for
// statement, and `repeat` is not one.
//
// `repeat_loop.va` is the legal shape (a variable accumulated in the body, the
// contribution after the loop). This file keeps everything and moves only the
// contribution inside, so the contribution is the one thing refused.
//
// EXACTLY ONE RULE IS BROKEN.
//
//! lrm 5.9.1
//! lrm 5.9
//! lrm 5.9:1
//! reject-only E0426
//! neighbour repeat_loop.va
`include "disciplines.vams"
module ch5_repeat_contribution(p);
  inout p; electrical p;
  analog begin
    repeat (2) I(p) <+ 1.0e-3;
  end
endmodule
