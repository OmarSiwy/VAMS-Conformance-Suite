// §5.6.7: "Indirect branch contributions shall not be used in conditional or
// looping statements, unless the conditional expression is a constant
// expression. The constant expression shall not include the analysis()
// function with an argument that can result in different return values during
// a single analysis, such as the "ic" or "nodeset" arguments."
//
// `analysis("ic")` is the clause's own example of what the carve-out excludes:
// it is true while the initial condition is being found and false afterwards,
// in ONE transient analysis, so the guarded constraint would exist for part of
// the analysis and not for the rest. indirect_under_parameter_condition.va
// is the same module with a parameter as the condition and must keep
// compiling; the pair differs only in the condition.
//
// VerA refuses it with E0412, "indirect contribution in a conditional or
// loop", whose message says the condition is not a constant expression.
//
//! lrm 5.6.7
//! lrm 5.6.7:3
//! reject-only E0412
//! neighbour indirect_under_parameter_condition.va
`include "disciplines.vams"
module b3_indirect_under_analysis_ic(p, n, ctrl);
  inout p, n, ctrl; electrical p, n, ctrl;
  analog begin
    if (analysis("ic"))
      V(p, n) : V(ctrl) == 2.0 * V(p, n);
  end
endmodule
