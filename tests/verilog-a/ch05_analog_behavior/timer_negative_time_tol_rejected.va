// §5.10.3.3 requires timer time_tol to be non-negative. Zero requests
// a suitable simulator value; the literal -1p is outside the allowed domain.
// E0517 identifies that argument violation. Legal timers with omitted
// tolerance run in timer_dynamic_period.va and event_timer.va.
// This is a compile-time refusal, so there is no runtime value to derive.
//
//! lrm 5.10.3.3
//! lrm 5.10.3.3:2
//! reject-only E0517
//! neighbour timer_dynamic_period.va
//! neighbour event_timer.va
`include "disciplines.vams"
module a10_timer_negative_time_tol(p);
  inout p;
  electrical p;
  integer n;
  analog begin
    @(timer(1n, 2n, -1p)) n = n + 1;
    I(p) <+ 0.0;
  end
endmodule
