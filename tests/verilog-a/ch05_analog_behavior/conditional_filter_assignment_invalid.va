// §5.7: "Analog filter functions cannot be used as part of the
// analog_expression syntax if the statement is conditionally executed during
// simulation." `V(c) > 0.0` is a probe of the solution, so the assignment to
// `x` is conditionally executed and the `ddt` in its right-hand side is
// illegal. The legal neighbour applies the same filter under a constant
// condition (`use_cap && analysis("tran")`), where §4.5.15 permits it.
//
//! lrm 5.7
//! lrm 5.7:1001
//! lrm 5.8.1
//! reject-only E0514
//! neighbour conditional_ddt_contribution_static.va
`include "disciplines.vams"
module ch5_conditional_filter_assignment(p, c);
  inout p, c; electrical p, c; real x;
  analog begin
    x = 0.0;
    if (V(c) > 0.0) x = ddt(V(p));
    I(p) <+ x + 0.0 * V(p);
  end
endmodule
