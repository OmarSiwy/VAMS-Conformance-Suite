// §5.10.3.3 the event is decided before its body changes the next schedule.
// At the second fire (2 ns), rate changes from 1 to 1.5. The event remains
// delivered, but the next period*rate grid point is 3 ns, before the obsolete
// 4 ns deadline. The host reads both count and body executions from eval.
`include "disciplines.vams"
module timer_body_function_controls(out, body);
  inout out, body;
  electrical out, body;
  parameter real period = 2n;
  parameter real gain = 1 from (0:inf);
  analog function real identity;
    input rate; real rate;
    begin identity = (rate > 1) ? sqrt(rate*rate) : rate; end
  endfunction
  analog function real scaled;
    input value; real value;
    begin scaled = gain * identity(value); end
  endfunction
  real rate;
  integer fires, executions;
  analog begin
    @(initial_step) rate = 1;
    @(timer(0, period * scaled(rate))) begin
      fires = fires + 1;
      executions = executions + 1;
      if (fires == 2) rate = 1.5;
    end
    I(out) <+ fires;
    I(body) <+ executions;
  end
endmodule
