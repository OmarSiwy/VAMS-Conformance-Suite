// VerA's `vera_timepoint` attribute (§2.9) on a statement inside a loop.
//
// A cached statement keeps one copy of what it assigns per timepoint. Inside
// a §5.9 loop it runs once per iteration of the loop with different inputs
// (here `i`), so one cache cannot stand for every run. E0532 names it. The
// legal neighbour puts the loop inside the statement, as
// vera_timepoint_cache.va's `for (i = 0; i < 3; i = i + 1) e[i] = ...` does.
//! lrm 2.9
//! reject-only E0532
//! neighbour vera_timepoint_cache.va
`include "disciplines.vams"
module reject_vera_timepoint_in_loop(p, n);
  inout p, n; electrical p, n;
  integer i;
  real e[0:2];
  analog begin
    for (i = 0; i < 3; i = i + 1)
      (* vera_timepoint *) e[i] = (i + 1) * $abstime;
    I(p, n) <+ V(p, n) / 1k + 1u * e[2];
  end
endmodule
