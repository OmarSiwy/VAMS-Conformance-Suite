// AMS §5.10.3.3 allows this source. VerA reports E0528 because the
// function input changes after its one effectful evaluation; recomputing
// the final timer control would repeat observable effects. This pins an
// implementation limit, not invalid-source clause coverage.
// Legal neighbors: timer_effectful_file_leaf.va and the emitted host's
// timer_body_precomputed_controls.va evaluate the effect once into a value.
//! reject-only E0528
//! neighbour timer_effectful_file_leaf.va
`include "disciplines.vams"
module timer_changed_effectful_random_function_input_rejected(p);
  inout p; electrical p;
  analog function real effect;
    input x; real x; integer seed, draw;
    begin seed = 17; draw = $random(seed); effect = x + abs(draw) * 1e-12; end
  endfunction
  real rate;
  integer visits;
  analog begin
    @(initial_step) rate = 1;
    @(timer(0, 2 * effect(rate))) rate = 1.5;
    I(p) <+ rate + visits;
  end
endmodule
