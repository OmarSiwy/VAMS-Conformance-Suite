// §5.6.8.2: "Hierarchical contributions are not allowed to branches that have
// been indirectly contributed to (see 5.6.7)." A hierarchical direct contribution
// to a branch that already has an indirect contribution is rejected.
//! lrm 5.6.8.2
//! reject-only E0415
`include "disciplines.vams"
module lrm_5_6_8_2_hierarchical_indirect_branch(p, n);
  inout p, n;
  electrical p, n;
  lrm_5_6_8_2_child child(p, n);

  analog begin
    // This indirect contribution to branch (p,n) in child is allowed
    V(child.p, child.n) : V(child.p) == V(child.n);

    // But a hierarchical direct contribution to the same branch is not allowed
    V(child.p, child.n) <+ 0.5;

    I(p, n) <+ 0.0;
  end
endmodule

module lrm_5_6_8_2_child(p, n);
  inout p, n;
  electrical p, n;
  analog I(p, n) <+ 0.0;
endmodule
