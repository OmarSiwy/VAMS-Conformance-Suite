// §5.6.8.1 Contributions to branches between hierarchical nets:
//
//   "Direct contribution statements can contribute to a branch between
//    combinations of local and hierarchical nets. In these cases, a new unnamed
//    branch is created in the module containing the direct contribution
//    statements. ... The simulator shall check if the contribution produces a
//    solvable set of equations, E.G. NO VOLTAGE SOURCE LOOPS CREATED."
//
// `hierarchical_contribution_voltage_loop_rejected.va` pins the two-branch loop
// (a source in parallel with a source). This file pins a loop that is NOT a
// parallel pair, so a check that only compared node pairs would miss it:
//
//     child:   V(x) <+ 3.0      x  -> gnd
//     child:   V(y) <+ 1.0      y  -> gnd
//     parent:  V(drv.x, drv.y) <+ 1.2      x -> y   (§5.6.8.1: a new branch, in the parent)
//
// No two of the three branches share both nodes, but together they are the
// cycle x -> y -> gnd -> x, made of potential sources only. KVL around it asks
// for 3.0 - 1.0 = 1.2, which is false; and were the numbers consistent (say
// 2.0), the three source currents would still be undetermined, because a
// current circulating around the loop satisfies every equation. Either way the
// set of equations is not solvable, which is what the clause says the simulator
// shall check.
//
// This is the second half of §5.6.8.1's own example, `V(top.drv.x, top.drv.y)
// <+ 1.2;`, placed into an instance that already pins both nets. In
// `hierarchical_contribution_creates_a_new_branch.va` the same statement
// is legal, because there the child's (x, y) path is a CONDUCTANCE — only one
// of the loop's branches is a potential source besides the parent's — and the
// design solves.
//
//! lrm 5.6.8.1
//! lrm 5.6.8
//! lrm 5.6.8.1:1
//! reject-only E0477
//! reject closes a loop of potential sources with a contribution from `drv`
//! neighbour hierarchical_contribution_creates_a_new_branch.va
`include "disciplines.vams"
module ch5_hier_vtriangle(g);
  inout g;
  electrical g;
  ch5_hier_vtriangle_child drv(g);
  analog begin
    V(drv.x, drv.y) <+ 1.2;
    I(g) <+ 0.0;
  end
endmodule

module ch5_hier_vtriangle_child(t);
  inout t;
  electrical t, x, y;
  analog begin
    V(x) <+ 3.0;
    V(y) <+ 1.0;
    I(t) <+ 0.0;
  end
endmodule
