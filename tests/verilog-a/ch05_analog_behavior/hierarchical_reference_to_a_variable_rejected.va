// §5.5.4 Creating unnamed branches using hierarchical net references:
//
//   "An access function in a module can have one or more hierarchical NET
//    references to nets in other module instances."
//
// The operand is a NET reference: the branch §5.5.4 creates runs between nets,
// because a branch is "a path of the flow between two nets" (§5.6.1.1) and an
// access function takes Syntax 5-5's `analog_net_reference` or
// `branch_reference`, never a variable. §6.7.1 closes the other door
// explicitly, in the list of usage rules for out-of-module references:
//
//   "IT SHALL BE AN ERROR TO ACCESS ANALOG VARIABLES HIERARCHICALLY."
//
// Below, `c.r` is a `real` VARIABLE of the child instance. `V(c.r)` would ask
// §5.5.4 to create an unnamed branch from a variable to ground — there is no
// such branch, because there is no node. `hierarchical_net_reference_probes_
// solve.va` is the legal form: the same parent reading `V(drv.a)` where `a` is a
// net of the child.
//
// EXACTLY ONE RULE IS BROKEN: rename `r` to a net of the child (`electrical r`)
// and the reference resolves.
//
//! lrm 5.5.4
//! lrm 6.7.1
//! lrm 6.7.1:3
//! lrm 5.5.1
//! lrm 5.5.1:1
//! reject-only E0901
//! reject names no net
//! neighbour hierarchical_net_reference_probes_solve.va
`include "disciplines.vams"
module ch5_hier_variable_ref(p);
  inout p;
  electrical p;
  ch5_hier_variable_ref_child c(p);
  analog I(p) <+ V(c.r);
endmodule

module ch5_hier_variable_ref_child(a);
  inout a;
  electrical a;
  real r;
  analog begin
    r = 1.0;
    I(a) <+ V(a);
  end
endmodule
