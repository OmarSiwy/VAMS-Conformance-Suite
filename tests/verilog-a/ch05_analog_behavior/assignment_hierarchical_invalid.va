// §5.7, the third semantic restriction on analog procedural assignments:
// "Hierarchical assignment of a variable from another scope/module is not
// allowed."
//
// Note which direction the rule runs. §5.5.4 makes a hierarchical NET reference
// legal on the right of an access function, and §5.6.8.1 makes one legal as the
// target of a contribution — hierarchical_access_unsupported.va and
// hierarchical_contribution_unsupported.va are those two clauses. A hierarchical
// VARIABLE, on the left of a procedural `=`, is the one hierarchical target the
// analog block may not write, because a variable is scope-owned storage and not
// a solver unknown the elaborator can share.
//
// procedural_assignments.va is the positive §5.7 fixture and keeps compiling;
// assignment_concatenation_invalid.va is the first of the three restrictions.
//
// VerA reached this by the shorter route for as long as it had no hierarchical
// references at all: the `.` stopped the statement at parse time (E0214) rather
// than at a scope check. It now PARSES a dotted name — §5.5.3's nature attribute
// reference needed that — so the refusal is where §5.7 puts it, on the assignment
// TARGET: E0316 quoting the hierarchical-assignment sentence. `x = 1.0` in the
// same position still compiles, which is what makes it a verdict on the target
// and not on the dot.
//
//! lrm 5.7
//! lrm 5.7:3
//! reject-only E0316
//! neighbour hierarchical_access_unsupported.va
//! neighbour hierarchical_contribution_unsupported.va
//! neighbour procedural_assignments.va
`include "disciplines.vams"
module ch5_assignment_hierarchical(p);
  inout p; electrical p; real x;
  analog begin
    x = 1.0;
    top.child.x = 1.0;       // illegal: a variable in another scope
    I(p) <+ x;
  end
endmodule
