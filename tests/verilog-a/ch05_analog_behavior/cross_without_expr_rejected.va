// §5.10.3.1, under Syntax 5-16: "cross ( expr [ , dir [ , time_tol [ ,
// expr_tol [ , enable ] ] ] ] ) where expr is required, and dir, time_tol,
// expr_tol, and enable are optional." The syntax agrees: the first slot of
// `cross (` is `analog_expression`, the only one that is not
// `analog_expression_or_null` or optional.
//
// `cross()` supplies no expr, so there is nothing to detect a zero crossing
// of. event_bounds_cross_legal.va calls cross() in the same position with its
// expr and every legal arrangement of the optional arguments, and must keep
// compiling.
//
// The expected refusal is the §5.10.3 event-argument code, E0517.
//
//! lrm 5.10.3.1
//! lrm 5.10.3.1:1
//! reject-only E0517
//! neighbour event_bounds_cross_legal.va
`include "disciplines.vams"
module b3_cross_without_expr(p);
  inout p; electrical p;
  integer n;
  analog begin
    @(cross()) n = n + 1;              // illegal: expr is required
    I(p) <+ 0.0;
  end
endmodule
