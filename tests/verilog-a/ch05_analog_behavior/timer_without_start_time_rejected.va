// §5.10.3.3, under Syntax 5-18: "timer ( start_time [ , period [ , time_tol
// [ , enable ] ] ] ) where start_time is required; period, time_tol and enable
// are optional arguments." The syntax's first slot is `analog_expression`,
// not `analog_expression_or_null`.
//
// `timer()` supplies no start_time, which is the absolute time the clause
// says the event "occurs at", so there is no event to schedule.
// event_timer.va is the same toggle with `timer(0.0, 1n, 1p)` and must keep
// compiling.
//
// The expected refusal is the §5.10.3 event-argument code, E0517.
//
//! lrm 5.10.3.3
//! lrm 5.10.3.3:1
//! reject-only E0517
//! neighbour event_timer.va
`include "disciplines.vams"
module b3_timer_without_start_time(p);
  inout p; electrical p; real state;
  analog begin
    @(timer()) state = 1.0 - state;    // illegal: start_time is required
    V(p) <+ transition(state, 0.0, 1p, 2p);
  end
endmodule
