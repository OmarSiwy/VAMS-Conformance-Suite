// VerA's `vera_timepoint` attribute (§2.9) over a statement that reads a probe.
//
// A `vera_timepoint` statement runs on the first evaluation of a timepoint
// and later iterations read back what it assigned. §4.4's probe is the
// iterate, which every Newton iteration moves, so a cached read of it would
// freeze the first iterate's value. E0530 names the probe. The legal
// neighbour, the same statement over `$abstime` and a held variable, is
// vera_timepoint_cache.va.
//! lrm 2.9
//! reject-only a probe (§4.4)
//! neighbour vera_timepoint_cache.va
`include "disciplines.vams"
module reject_vera_timepoint_probe(p, n);
  inout p, n; electrical p, n;
  real w;
  analog begin
    (* vera_timepoint *) w = 2.0 * V(p, n);
    I(p, n) <+ V(p, n) / 1k + w;
  end
endmodule
