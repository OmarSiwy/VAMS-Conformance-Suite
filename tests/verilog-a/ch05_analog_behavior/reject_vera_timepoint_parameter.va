// VerA's `vera_timepoint` attribute (§2.9) with a value the model card decides.
//
// §2.9: `attr_spec ::= attr_name [ = constant_expression ]`. A parameter IS a
// constant expression, but the answer decides the code the device is built
// with, before any model card exists, so the value must fold without one.
// E0529 names that. The legal neighbour, `(* vera_timepoint = 1 *)`, is in
// vera_timepoint_cache.va.
//! lrm 2.9
//! reject-only E0529
//! neighbour vera_timepoint_cache.va
`include "disciplines.vams"
module reject_vera_timepoint_parameter(p, n);
  inout p, n; electrical p, n;
  parameter integer cache = 1;
  real w;
  analog begin
    (* vera_timepoint = cache *) w = 2.0 * $abstime;
    I(p, n) <+ V(p, n) / 1k + w;
  end
endmodule
