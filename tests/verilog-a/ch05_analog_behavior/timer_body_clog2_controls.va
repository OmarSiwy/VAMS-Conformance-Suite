// AMS §9.14 treats the 32-bit integer operand of $clog2 as unsigned:
// $clog2(1)=0, and $clog2(-1)=32. At the second event, code changes from one
// to minus one. §5.10.3.3 therefore changes period*(1+$clog2(code)/64)
// from 2 ns to 3 ns for the next deadline. tests/fixtures/ch05_analog_behavior/timer_host.zig checks the
// emitted breakpoint, event count, body count, and rollback/retry.
`include "disciplines.vams"
module timer_body_clog2_controls(out, body);
  inout out, body;
  electrical out, body;
  parameter real period = 2n;
  integer code, fires, executions;
  analog begin
    @(initial_step) code = 1;
    @(timer(0, period * (1.0 + $clog2(code) / 64.0))) begin
      fires = fires + 1;
      executions = executions + 1;
      if (fires == 2) code = -1;
    end
    I(out) <+ fires;
    I(body) <+ executions;
  end
endmodule
