// VerA's `vera_timepoint` attribute (§2.9) over a stateful analog operator.
//
// §4.5.2: an analog operator keeps state that advances once per accepted
// step and reads its input at every evaluation. Inside a cached statement it
// would see only the first iteration of each timepoint. E0530 names it. The
// legal neighbour, a statement of `$abstime` and held state, is
// vera_timepoint_cache.va.
//! lrm 2.9
//! reject-only the analog operator `idt`
//! neighbour vera_timepoint_cache.va
`include "disciplines.vams"
module reject_vera_timepoint_operator(p, n);
  inout p, n; electrical p, n;
  real w;
  analog begin
    (* vera_timepoint *) w = idt($abstime, 0.0);
    I(p, n) <+ V(p, n) / 1k + 1u * w;
  end
endmodule
