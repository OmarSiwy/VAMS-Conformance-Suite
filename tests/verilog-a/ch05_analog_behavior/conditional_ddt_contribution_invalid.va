// §5.8.1: "If any of the conditionally-executed statements (analog_statement_
// or_null) contains an analog operator, the conditional expression (analog_
// expression) shall be a analysis_or_constant_expression." §4.5.15 says the
// same of every conditional and names no exemption for a contribution:
// "Analog operators shall not be used inside conditional (if, case, or ?:)
// statements unless the conditional expression controlling the statement
// consists of terms which can not change their value during the course of a
// simulation."
//
// `ddt` is §4.5.3's analog operator and `V(p, n) > 0.0` moves on every Newton
// iteration, so this module is illegal. conditional_filter_invalid.va pins the
// rule for an operator in an ordinary expression; this is the same rule for a
// `ddt` on the RIGHT-HAND SIDE of a contribution, which lowers through the
// §5.6.1.2 charge split instead of the operator path and used to compile
// cleanly.
//
// The positive side, the same contribution under an analysis_or_constant
// condition, is conditional_ddt_contribution_static.va.
//
//! lrm 5.8.1
//! lrm 4.5.15
//! lrm 4.5.15:1
//! lrm 5.6.5
//! lrm 5.6.5:3
//! lrm 5.8.1:1
//! reject-only E0514
//! neighbour conditional_ddt_contribution_static.va
`include "disciplines.vams"
module ch5_conditional_ddt_contribution(p, n);
  inout p, n; electrical p, n;
  analog begin
    if (V(p, n) > 0.0) I(p, n) <+ ddt(V(p, n));
  end
endmodule
