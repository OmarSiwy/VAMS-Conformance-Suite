// §5.5.3, the sentence immediately after Syntax 5-4: "This syntax shall not be
// used for the access, ddt_nature, or idt_nature attributes of a nature, nor
// any other attribute whose value is not a constant expression."
//
// `abstol` is a real and is what the clause's twocap example passes to ddt();
// `access` is the nature's access-function IDENTIFIER (§3.6.1 — `V` for the
// Voltage nature), so `a.potential.access` is not a value at all and cannot be
// the tolerance argument of anything. The two `ddt_nature`/`idt_nature`
// attributes are identifiers for the same reason.
//
// This is the negative half of nature_attribute_unsupported.va, which is the
// twocap example verbatim with `a.potential.abstol` and must keep compiling on
// any conforming tool. The two files differ in one identifier, which is the
// whole point: the syntax is legal, the attribute chosen is not.
//
// VerA used to reach the right verdict by the shorter route — E0207, because it
// could not parse a nature attribute reference at all, so the `.` stopped the
// expression before any attribute was looked up, and the legal abstol form was
// refused with it. It now parses Syntax 5-4 and this fixture pins the §5.5.3 ban
// itself: E0359 fires on the ATTRIBUTE, and only on it, which is why the legal
// sibling compiles.
//
//! lrm 5.5.3
//! lrm 5.5.3:1
//! lrm A.8.9
//! reject-only E0359
//! neighbour nature_attribute_unsupported.va
`include "disciplines.vams"
module ch5_nature_attribute_nonconstant(a, b);
  inout a, b; electrical a, b;
  parameter real c = 1p;
  analog begin
    // illegal: `access` is an identifier, not a constant expression
    I(a, b) <+ c*ddt(V(a, b), a.potential.access);
  end
endmodule
