// §5.11: "The continue and break statements can only be used in a loop." The
// function body here has NO loop, so its `break` has no target — and the loop
// at the CALL SITE is not one: §4.7.1 makes the function its own scope, and a
// statement of the body is not a statement of the caller's loop body, however
// the inliner (§4.7.3) splices the two CFGs together.
//
// This is jump_outside_loop_invalid.va moved inside a function, and it must
// stay the same E0404 — it used to compile instead, with the `break` binding
// the caller's `while` and exiting it on the first pass: an accumulator meant
// to reach 4 * 101 = 404 read 101, silently.
//
// jump_in_function_binds_function_loop.va is the legal sibling, where the
// function brings its own loop for the break to bind.
//
//! lrm 5.11
//! lrm 4.7.1
//! reject-only E0404
//! neighbour jump_in_function_binds_function_loop.va
//! lrm 5.11:1001
`include "disciplines.vams"
module ch5_jump_in_function_outside_loop(p);
    inout p; electrical p;
    integer j, acc;

    analog function integer bump;
        input x;
        integer x;
        begin
            bump = x + 1;
            if (x > 10) break; // no loop anywhere in this function
        end
    endfunction

    analog begin
        acc = 0;
        j = 0;
        while (j < 4) begin
            acc = acc + bump(100);
            j = j + 1;
        end
        I(p) <+ acc * 1.0e-6;
    end
endmodule
