// §5.10.3.1: "In addition, cross() is not allowed in the repeat and while
// iteration statements. It is allowed in the analog_for statements."
//
// A `repeat` body runs its count of times at every evaluation, so a cross()
// inside it would be one detector sampled several times per solution: it has
// no single history to detect a crossing in. cross_under_genvar_condition.va
// holds cross() in an analog_for, the form the sentence allows, and must keep
// compiling. cross_in_while_rejected.va is the `while` half of the
// sentence, kept apart so that refusing one loop cannot hide accepting the
// other.
//
// VerA refuses it with E0707, "event control statement under a runtime
// condition or in a loop".
//
//! lrm 5.10.3.1
//! lrm 5.10.3.1:8
//! reject-only E0707
//! neighbour cross_under_genvar_condition.va
`include "disciplines.vams"
module b3_cross_in_repeat(p);
  inout p; electrical p;
  integer n;
  analog begin
    repeat (2) @(cross(V(p), 1)) n = n + 1;           // illegal: cross() in repeat
    I(p) <+ 0.0;
  end
endmodule
