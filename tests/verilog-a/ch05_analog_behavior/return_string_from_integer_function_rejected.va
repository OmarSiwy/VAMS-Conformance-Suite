// §5.11 Jump statements: "In a function returning a value, the return
// statement shall have an expression of the correct type."
//
// `triple` is declared `integer` and returns `s`, a `string` variable. §3.3
// settles that this is the wrong type and not a conversion: "A string literal
// can be assigned to a string or an integral type. ... A string cannot be
// assigned to an integral type." `s` is a string-typed VARIABLE, not a
// literal, so the integral-literal reading does not apply. The return has no
// value of the function's type to give.
//
// return_expression_of_the_function_type.va is the same module with
// `return 3 * k;` and must keep compiling. The expected refusal is the one
// VerA already gives the same mismatch in an assignment, E0354 "a string
// value cannot be assigned to a numeric variable".
//
//! lrm 5.11
//! lrm 5.11:1
//! reject-only E0354
//! neighbour return_expression_of_the_function_type.va
`include "disciplines.vams"
module b3_return_string_from_integer_function(p);
  inout p; electrical p;

  analog function real scale;
    input x;
    real x;
    begin
      return 2.5 * x;
    end
  endfunction

  analog function integer triple;
    input k;
    integer k;
    string s;
    begin
      s = "six";
      return s;                         // illegal: a string, from an integer function
    end
  endfunction

  analog begin
    I(p) <+ scale(2.0) * 0.0 + triple(2) * 0.0;
  end
endmodule
