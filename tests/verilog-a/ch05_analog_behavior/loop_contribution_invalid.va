// §5.9, the third of three blanket restrictions on repeat/while/non-genvar-for:
// "Contribution statements are not allowed". Only the §5.9.3 analog_for is
// exempt — its trip count is fixed at elaboration, so the set of branches it
// stamps is known before the solve. A runtime loop's is not, and the number of
// equations may not depend on data.
//
// for_loop.va is the same loop with the contribution moved out after it, which
// is the legal way to write this and must keep compiling.
//
// E0426 ("contribution inside a runtime loop") is VerA's code for this rule, and
// it replaces the phase label pinned before the code existed.
//
//! lrm 5.9
//! lrm 5.9:1
//! reject-only E0426
//! neighbour for_loop.va
`include "disciplines.vams"
module ch5_loop_contribution(p);
  inout p; electrical p; integer i;
  analog begin
    for (i = 0; i < 2; i = i + 1) I(p) <+ 1m;
  end
endmodule
