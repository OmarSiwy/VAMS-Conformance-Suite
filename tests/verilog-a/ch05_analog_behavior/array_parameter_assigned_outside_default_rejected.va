// §5.7: "The array on the LHS of the assignment shall be an array variable, a
// slice of an array variable or an array parameter (when the default value of
// the parameter is assigned)."
//
// The parenthetical is the boundary under test. An array parameter is a legal
// target in exactly one place, its own declaration's default (`= '{1, 2}`
// below). `A = B` in the analog block assigns it anywhere else, so its LHS is
// none of the three things the sentence lists. array_assignment_compatible.va
// is the same module with A an array VARIABLE, and must keep compiling.
//
// The expected refusal is E0312, "cannot assign to a parameter", at A.
//
//! lrm 5.7
//! lrm 5.7:4
//! reject-only E0312
//! neighbour array_assignment_compatible.va
`include "disciplines.vams"
module b3_array_parameter_assigned_outside_default(p);
  inout p; electrical p;
  parameter integer A[0:1] = '{1, 2};    // legal: the default
  integer B[0:1];
  analog begin
    B[0] = 3;
    B[1] = 4;
    A = B;                               // illegal: not the default
    I(p) <+ 0.0;
  end
endmodule
