// §5.9, the first of three blanket restrictions on repeat/while/non-genvar-for:
// "Analog filter functions are not allowed". Only the §5.9.3 analog_for is
// exempt, because its trip count is fixed at elaboration and each unrolled
// instance can be given its own state (§4.5.15). A runtime `for` cannot: the
// number of ddt() instances would depend on data, and §4.5.15's one-state-per-
// textual-instance rule has nothing to attach to.
//
// for_loop.va and for_zero_iterations.va are the same loop with no operator in
// it, and must keep compiling.
//
// VerA reaches the rejection through E0514, which states the §5.8.1 form of the
// same principle — an analog operator whose execution depends on something that
// moves during the solve. The code is what is pinned.
//
//! lrm 5.9
//! lrm 5.9:1
//! reject-only E0514
//! neighbour for_loop.va
//! neighbour for_zero_iterations.va
`include "disciplines.vams"
module ch5_loop_filter(p);
  inout p; electrical p; integer i; real x;
  analog begin
    x = 0.0;
    for (i = 0; i < 2; i = i + 1) x = x + ddt(V(p));
    I(p) <+ x;
  end
endmodule
