// §5.6.7: "Indirect branch contributions shall not be used in conditional or
// looping statements, unless the conditional expression is a constant
// expression."
//
// An indirect contribution replaces a branch's equation with a constraint, so a
// guard the solver can re-evaluate would change the SIZE of the equation system
// between Newton iterations. `V(c) > 0.5` is a probe comparison — it moves on
// every iteration — so it is not the constant expression the carve-out asks
// for. indirect_contribution.va and multiple_indirect.va are the unguarded,
// legal form.
//
//! lrm 5.6.7
//! lrm 5.6.7:2
//! reject-only E0412
//! neighbour indirect_contribution.va
//! neighbour multiple_indirect.va
`include "disciplines.vams"
module ch5_conditional_indirect(p, c);
  inout p, c; electrical p, c;
  analog begin
    if (V(c) > 0.5) V(p) : I(p) == 0.0;
    I(c) <+ 0.0;
  end
endmodule
