// §5.10.3.4 on absdelta(): "This function is only allowed in an initial or
// always block of a Verilog-AMS module." An `analog` block is neither, so
// rejecting this file is conformance, not a VerA limitation — the header this
// file used to carry said the opposite.
//
// VerA implements absdelta in a digital initial/always block now (the
// mixed-signal kernel's monitor, ch07 m01_10 and m02_13), so E0513 is the
// §5.10.3.4 placement diagnostic, and this file pins its wording rather than
// the code alone: it used to read "absdelta() is not implemented", the right
// verdict by the shorter route.
//
// The other §5.10.3.4 constraints — delta and the tolerances non-negative, the
// enable argument an integer — are constraints on a legal call site and cannot
// be pinned here; they belong with a fixture that has one.
//
//! lrm 5.10.3.4
//! reject-only E0513
//! reject only allowed in an initial or always block
//! lrm 5.10.3.4:1001
//! neighbour ../../verilog-ams/ch05_analog_behavior/absdelta_samples_analog_changes.va
`include "disciplines.vams"
module ch5_absdelta(p);
  inout p; electrical p; real x;
  analog @(absdelta(V(p), 1p)) x = V(p);
endmodule
