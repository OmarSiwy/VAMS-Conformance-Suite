// §5.6.8.2, the clause's last sentence: "Hierarchical contributions are not
// allowed to branches that have been indirectly contributed to (see 5.6.7)."
//
// a02_08 is the legal form and must keep compiling: the child potential-
// sources its named branch `br` with `V(br) <+ 0.5`, the parent reaches the
// same branch as `V(drv.br) <+ 1.8`, and the two accumulate (2.3 V). Here the
// child instead drives `br` INDIRECTLY, `V(br) : V(br) == 0.5` ("drive V(br)
// so that V(br) == 0.5"), and the parent's hierarchical direct contribution
// is unchanged. Nothing else differs, so the refusal is the clause's: a branch
// an indirect contribution owns has no accumulator for a parent to add to.
//
// Which statement the diagnostic lands on depends on the order the two units
// lower in, and VerA has one code for each order, both naming this conflict
// (§5.6.7.2, "Once a value is indirectly assigned to a branch, it cannot be
// contributed to using the branch contribution operator <+"): E0409 "branch is
// already indirectly assigned" at the `<+`, or E0415 "branch already has a
// direct contribution" at the `:`. The pin is the one this tree fires.
//
//! lrm 5.6.8.2
//! lrm 5.6.8.2:2
//! reject-only E0409
//! neighbour hierarchical_named_branch_accumulates.va
`include "disciplines.vams"
module b3_hier_contribution_indirect_branch(g);
  inout g;
  electrical g;
  b3_hier_contribution_indirect_branch_child drv(g);
  analog begin
    V(drv.br) <+ 1.8;          // illegal: br is indirectly contributed to
    I(g) <+ 0.0;
  end
endmodule

module b3_hier_contribution_indirect_branch_child(b);
  inout b;
  electrical b, x;
  branch (x, b) br;
  analog begin
    V(br) : V(br) == 0.5;
    I(x) <+ V(x)/1000.0;
    I(b) <+ 0.0;
  end
endmodule
