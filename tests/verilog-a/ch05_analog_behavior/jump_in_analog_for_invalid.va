// §5.11: "The continue and break statements cannot be used inside an analog
// for loop. Refer 5.9.3."
//
// A distinct rule from jump_outside_loop_invalid.va: this `break` IS inside a
// loop, but the loop is the §5.9.3 analog_for, whose genvar control is unrolled
// at elaboration. There is no runtime iteration for a jump to abandon, and each
// unrolled body owns its own analog operator state (§4.5.15), so the statement
// has no meaning here.
//
// E0440 names that rule. (Until 2026-10 VerA counted only runtime loops as
// loops, so this read E0404 "outside a loop": the right verdict, the wrong
// reason.) The legal neighbour, a procedural for nested in the analog_for
// with the jump inside it, is jump_in_runtime_for_in_analog_for.va.
//
//! lrm 5.11
//! lrm 5.9.3
//! reject-only E0440
//! neighbour jump_in_runtime_for_in_analog_for.va
//! lrm 5.11:1003
`include "disciplines.vams"
module ch5_jump_in_analog_for(p);
  inout p; electrical p; genvar k; real x;
  analog begin
    x = 0.0;
    for (k = 0; k < 3; k = k + 1) begin
      if (k == 1) break;
      x = x + 1.0;
    end
    I(p) <+ x;
  end
endmodule
