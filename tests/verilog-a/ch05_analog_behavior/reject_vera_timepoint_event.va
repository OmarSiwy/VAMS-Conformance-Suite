// VerA's `vera_timepoint` attribute (§2.9) over an event control.
//
// §5.10 events are detected per evaluation (a `cross` on the iterate) and a
// cached statement does not run on the later iterations of a timepoint, so
// an event inside one could be missed. E0530 names it. The legal neighbour,
// the event outside the statement, is vera_timepoint_cache.va's
// `@(timer(0, 1.0)) k = k + 1;`.
//! lrm 2.9
//! reject-only an event control (§5.10)
//! neighbour vera_timepoint_cache.va
`include "disciplines.vams"
module reject_vera_timepoint_event(p, n);
  inout p, n; electrical p, n;
  integer k;
  analog begin
    (* vera_timepoint *) begin
      @(timer(0, 1.0)) k = k + 1;
    end
    I(p, n) <+ V(p, n) / 1k + 1u * k;
  end
endmodule
