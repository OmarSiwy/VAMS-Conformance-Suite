// A VerA limit, not an LRM rule (specification/Vague_Decisions.md §7, E0997). §5.4.3:
// "The port access function accesses the flow into a port of a module ...
// I(<a>) accesses the current through module port a." Inside an instance, a
// module's own `I(<a>)` is the flow into THAT instance's port a, which is
// not the flow into the port of the module above it that the net is joined
// to. Elaboration joins the port onto the parent's net, so until 2026-10-08
// VerA read the joined net's port flow: the top's port flow when the net was
// a top port (both leaves below would have read 7.5e-4), else E0508.
//
// VerA has the instance's own port flow only as a sum of its contributions,
// read from a module above it after its blocks (`lower/expr.zig`
// `instancePortFlow`), so the read from inside is refused by name.
//
// port_access_hierarchical_instance.va is the legal neighbour: the same two
// leaves on one top port, their port flows read from the top as
// `I(<u1.a>)`, `I(<u2.a>)`.
//
//! lrm 5.4.3
//! reject-only E0997
//! neighbour port_access_hierarchical_instance.va
`include "disciplines.vams"
module paop_g(a);
  inout a; electrical a;
  parameter real r = 1k;
  real seen;
  analog begin
    I(a) <+ V(a) / r;
    seen = I(<a>);
  end
endmodule
module paop_top(p);
  inout p; electrical p;
  paop_g #(.r(2k)) u1(p);
  paop_g #(.r(1k)) u2(p);
endmodule
