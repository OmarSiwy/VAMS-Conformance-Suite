// §5.7: "An array, or a slice of such an array, shall be assignment compatible
// with any other such array or slice if all the following conditions are
// satisfied: — The element types of source and target shall be equivalent.
// — Every dimension of the source array shall have the same number of
// elements as the target array."
//
// Same element COUNT (two and two), different element TYPE: A holds integers,
// R holds reals. So only the first condition fails, which is the one this file
// isolates (assignment_array_mismatch_invalid.va is the second, the count).
// §4.2.1.1's real-to-integer conversion is a rule for a scalar assignment; the
// array sentence states equivalence and gives no conversion. 3.0 and 4.0 are
// integral on purpose, so a tool cannot excuse the copy as lossless.
// array_assignment_compatible.va is the same module with an integer source
// and must keep compiling.
//
// VerA refuses it with E0429, "incompatible array assignment", whose message
// names the two element types.
//
//! lrm 5.7
//! lrm 5.7:7
//! lrm 5.7:8
//! reject-only E0429
//! neighbour array_assignment_compatible.va
//! lrm 5.7:6
`include "disciplines.vams"
module b3_array_assignment_element_types_differ(p);
  inout p; electrical p;
  integer A[0:1];
  real R[0:1];
  analog begin
    R[0] = 3.0;
    R[1] = 4.0;
    A = R;                               // illegal: integer <- real elements
    I(p) <+ 0.0;
  end
endmodule
