// A.6.5, the whole production:
//
//     disable_statement ::=
//           disable hierarchical_task_identifier ;
//         | disable hierarchical_block_identifier ;
//
// The operand is a TASK name or a BLOCK name. Nothing else derives, so
// `disable r` where `r` is a real variable has no parse, and §4.7.1 rules the
// other alternative out for the analog context in the same breath — an analog
// function is not a task, and Verilog-AMS gives the analog block no task to
// disable. In an analog block the only legal operand is a named-block label.
//
// This is the ONE refusal this row adds. The two refusals that already exist —
// tests/fixtures/annex_c_analog_subset/disable_rejected.va and
// annex_a_syntax/disable_statement.va — both pin the same thing, that a
// disable outside an event statement has no derivation (E0401, A.6.4). Neither
// reaches the operand, because E0402 "`disable` is not implemented" fires the
// moment the statement IS in event position, so no diagnostic in VerA has ever
// looked at the name.
//
// The name here resolves to something real, so this is not a
// "name-not-found" test: `r` is a declared module variable, visible at the
// point of use, and the block label `work` that WOULD be legal is declared in
// the same file and left unused. The fixture therefore pins the distinction A.6.5
// draws between an identifier and a block identifier, which is the check that
// has to exist before fixtures 01-03 can be implemented safely — without it,
// `disable r` would be accepted and then silently lowered as a jump to nowhere.
//
// It stays a refusal and not an assertion because there is no conforming
// behaviour to assert: the program is illegal.
//
// OBSERVED TODAY: error[E0402]: `disable` is not implemented — which is the
// right verdict for the wrong reason, so the `//! reject` substring below does
// NOT match and the fixture fails, as it must until the operand is resolved.
//
//! lrm 5.3.2
//! inherited IEEE 1364-2005 10.3
//! reject-only names no named block
`include "disciplines.vams"
module a03_disable_bad_target(p);
  inout p; electrical p;
  real r;
  analog begin : work
    r = 1.0;
    @(initial_step) disable r;
    I(p) <+ 0.0;
  end
endmodule
