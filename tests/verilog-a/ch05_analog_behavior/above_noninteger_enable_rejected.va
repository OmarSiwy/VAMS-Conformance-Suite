// §5.10.3.2: "The enable argument, if specified, shall evaluate to an integer,
// all other arguments are real expressions."
//
// The sentence draws the line between the slots: time_tol and expr_tol may be
// any real, the enable may not. 0.5 is not an integer, and the clause reads
// the enable only as zero or nonzero, so it supplies no rounding that would
// make 0.5 one of them. The same reading is pinned for cross()'s dir
// (cross_dir_noninteger_invalid.va) and absdelta()'s enable
// (../ch07_mixed_signal/event_bounds_absdelta_noninteger_enable_rejected.va),
// both E0517. above_enable_integer.va is this module with enable 1 and must
// keep compiling.
//
//! lrm 5.10.3.2
//! lrm 5.10.3.2:2
//! reject-only E0517
//! neighbour above_enable_integer.va
`include "disciplines.vams"
module b3_above_noninteger_enable(p, c);
  inout p, c; electrical p, c; real sample;
  analog begin
    @(above(V(c) - 0.5, 1p, 1u, 0.5)) sample = V(p);   // illegal: enable 0.5
    I(p) <+ sample;
  end
endmodule
