// §5.9.3 Analog For Statements: "The analog_loop_generate_statement puts the
// additional restriction upon the procedural assignment and conditional
// expressions of the for-loop to be statically evaluatable. Verilog-AMS HDL
// provides genvar-derived expressions for this purpose."
//
// analog_genvar_loop.va is the clause's genvarexp example with its condition
// `k <= width`, a genvar against a parameter: statically evaluatable, and it
// must keep compiling. Here the bound reads a probe, `V(dt[1]) > 0.0`, which
// is known only once the solver has a value for the node and may change
// between Newton iterations. The loop's trip count would then be a property
// of the solution rather than of the source, and the body holds a ddt(), an
// analog operator whose instance count must be fixed. Nothing else differs.
//
// VerA refuses it with E0418, "genvar loop condition is not a constant
// expression".
//
//! lrm 5.9.3
//! lrm 5.9.3:1000
//! reject-only E0418
//! neighbour analog_genvar_loop.va
`include "disciplines.vams"
module b3_genvar_loop_condition_reads_a_probe(out, dt);
  parameter integer width = 3;
  output out;
  input [1:width] dt;
  electrical out;
  electrical [1:width] dt;
  genvar k;
  real tmp;
  analog begin
    tmp = 0.0;
    for (k = 1; k <= ((V(dt[1]) > 0.0) ? width : 1); k = k + 1) begin
      tmp = tmp + V(dt[k]);
      V(out) <+ ddt(V(dt[k]));
    end
  end
endmodule
