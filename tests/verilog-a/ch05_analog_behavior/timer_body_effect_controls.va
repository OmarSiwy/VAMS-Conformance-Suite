// §5.10.3.3 the event is decided before its body changes the next schedule.
// At the second fire (2 ns), rate changes from 1 to 1.5. The event remains
// delivered, but the next period*rate grid point is 3 ns, before the obsolete
// 4 ns deadline. The host reads both count and body executions from eval.
`include "disciplines.vams"
module timer_body_effect_controls(out, body, calls, mark);
  inout out, body, calls, mark;
  electrical out, body, calls, mark;
  parameter real period = 2n;
  parameter real gain = 1 from (0:inf);
  analog function real identity;
    input value; real value;
    begin identity = value; end
  endfunction
  analog function real effect;
    input value; inout count; output stamp;
    real value; integer count, stamp;
    // The card-derived return stays unchanged while rate changes outside
    // this leaf, within a pure wrapper. Copy-outs execute once at the call.
    begin count = count + 1; stamp = value; effect = value; end
  endfunction
  real rate;
  integer visits, stamp;
  integer fires, executions;
  analog begin
    @(initial_step) rate = 1;
    @(timer(0, period * identity(rate * effect(gain, visits, stamp)))) begin
      fires = fires + 1;
      executions = executions + 1;
      stamp = 100 + fires;
      if (fires == 2) rate = 1.5;
    end
    I(out) <+ fires;
    I(body) <+ executions;
    I(calls) <+ visits;
    I(mark) <+ stamp;
  end
endmodule
