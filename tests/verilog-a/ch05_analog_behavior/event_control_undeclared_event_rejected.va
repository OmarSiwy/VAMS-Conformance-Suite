// §5.10.4: "An event name shall be declared explicitly before it is used." The
// declaration is Syntax 5-20's `event list_of_event_identifiers ;`.
//
// `tick` below is used in an event control and declared nowhere: not as an
// event, a net, a variable or a parameter. The legal named event, declared
// and then waited on, is named_event_has_no_time_duration.va.
//
//! lrm 5.10.4
//! lrm 5.10.4:1
//! reject-only E0705
//! neighbour ../../verilog-ams/ch05_analog_behavior/named_event_has_no_time_duration.va
`include "disciplines.vams"
module ch5_event_control_undeclared_event(p, n);
  inout p, n; electrical p, n;
  real y;
  analog begin
    @(tick) y = 1.0;
    I(p, n) <+ V(p, n);
  end
endmodule
