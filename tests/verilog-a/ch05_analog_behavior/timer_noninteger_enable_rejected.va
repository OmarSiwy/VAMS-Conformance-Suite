// §5.10.3.3: "The enable argument, if specified, shall evaluate to an
// integer."
//
// 0.5 does not. The clause gives no rounding for this slot and reads enable
// only as zero ("inactive") or nonzero, so a real 0.5 is ill-formed rather
// than a third value: the same reading the suite already pins for cross()'s
// dir (cross_dir_noninteger_invalid.va) and absdelta()'s enable
// (../ch07_mixed_signal/event_bounds_absdelta_noninteger_enable_rejected.va),
// both E0517. timer_enable_integer.va is this module with enable 1 and must
// keep compiling.
//
//! lrm 5.10.3.3
//! lrm 5.10.3.3:3
//! reject-only E0517
//! neighbour timer_enable_integer.va
`include "disciplines.vams"
module b3_timer_noninteger_enable(p);
  inout p; electrical p; real state;
  analog begin
    @(timer(0.0, 1n, 1p, 0.5)) state = 1.0 - state;   // illegal: enable 0.5
    V(p) <+ transition(state, 0.0, 1p, 2p);
  end
endmodule
