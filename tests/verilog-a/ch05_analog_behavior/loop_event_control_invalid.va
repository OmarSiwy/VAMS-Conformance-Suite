// §5.9, the second of three blanket restrictions on repeat/while/non-genvar-for:
// "Event control statements are not allowed". §5.8 states the conditional half
// of the same rule, and conditional_event_control_invalid.va pins that one.
//
// A monitored or global event is a detector the kernel advances once per
// accepted timestep, outside the Newton loop, so its state moves whether or not
// the loop body that encloses it ran. while_loop.va and repeat_loop.va are the
// same loops without an event, and must keep compiling.
//
//! lrm 5.9
//! lrm 5.9:1
//! reject-only E0707
//! neighbour repeat_loop.va
//! neighbour while_loop.va
`include "disciplines.vams"
module ch5_loop_event_control(p);
  inout p; electrical p; integer i; real x;
  analog begin
    x = 0.0;
    for (i = 0; i < 2; i = i + 1) @(initial_step) x = 1.0;
    I(p) <+ x;
  end
endmodule
