// §5.3.2: "Named and ordered parameter overrides at module instantiation can
// only affect parameters declared at module scope." `local_gain` is declared
// inside the named block `calc`, not at module scope, so the named override
// `#(.local_gain(3.0))` names no parameter of the child. The legal neighbour
// overrides a module-scope parameter of its child instance.
//
//! lrm 5.3.2
//! lrm 5.3.2:1004
//! reject-only E0907
//! neighbour port_access_hierarchical_instance.va
`include "disciplines.vams"
module ch5_block_param_override_top(p);
  inout p; electrical p;
  ch5_block_param_override_child #(.local_gain(3.0)) u1(p);
  analog begin
    I(p) <+ V(p);
  end
endmodule

module ch5_block_param_override_child(p);
  inout p; electrical p;
  analog begin : calc
    parameter real local_gain = 2.0;
    I(p) <+ 0.0 * local_gain * V(p);
  end
endmodule
