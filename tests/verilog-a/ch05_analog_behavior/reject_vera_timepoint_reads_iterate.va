// VerA's `vera_timepoint` attribute (§2.9) over a statement that reads the
// iterate through a variable.
//
// The statement names no probe, so E0530 does not fire, but `y` is chosen by
// a branch on V(p): a §4.4 probe that every Newton iteration moves. A cached
// `w` would keep the first iteration's choice. E0531 follows the value and
// the branch that steers it. The legal neighbour reads a §5.10 held variable
// and `$abstime` instead, which no iteration moves: vera_timepoint_cache.va.
//! lrm 2.9
//! reject-only E0531
//! neighbour vera_timepoint_cache.va
`include "disciplines.vams"
module reject_vera_timepoint_reads_iterate(p, n);
  inout p, n; electrical p, n;
  real w, y;
  analog begin
    if (V(p) > 0.0) y = 1.0; else y = 2.0;
    (* vera_timepoint *) w = y * 2.0;
    I(p, n) <+ V(p, n) / 1k + 1u * w;
  end
endmodule
