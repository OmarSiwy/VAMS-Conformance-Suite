// §2.8.1: "Neither the leading backslash character nor the terminating white
// space is considered to be part of the identifier. Therefore, an escaped
// identifier \cpu3 is treated the same as a non-escaped identifier cpu3."
//
// So `real x;` and `real \x ;` below are two declarations of ONE name, not two
// names that happen to spell alike. That is exactly what makes the sentence
// observable in a passing compiler: if the backslash or the terminating space
// were kept, the declarations would be distinct and the module would compile;
// because neither is part of the name, the second declaration is a duplicate
// and §6.8's E0362 fires ("one identifier declares one item in a scope").
//
// escaped_identifiers.va is the legal neighbour, and the positive half of
// the same sentence: it writes `\trim ` and reads the storage back through
// plain `trim`.
//
//! lrm 2.8.1
//! lrm 2.8.1:1001
//! reject-only E0362
//! neighbour escaped_identifiers.va
`include "disciplines.vams"
module ch02_escaped_and_plain_same_name_rejected(p, n);
    inout p, n;
    electrical p, n;
    real x;
    real \x ;
    analog I(p, n) <+ V(p, n);
endmodule
