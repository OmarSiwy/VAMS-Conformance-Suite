// §2.8: "An identifier shall be used to give an object a unique name so it can
// be referenced." Two declarations of the same name in one scope defeat the
// uniqueness: a later read of `x` has two objects to reach.
//
// §6.8 states the consequence for declarations ("one identifier declares one
// item in a scope — the earlier declaration is unreachable") and E0362 is the
// refusal. simple_identifiers.va is the legal neighbour: every name there is
// declared once and read back.
//
//! lrm 2.8
//! lrm 2.8:1
//! reject-only E0362
//! neighbour simple_identifiers.va
`include "disciplines.vams"
module ch02_duplicate_identifier_rejected(p, n);
    inout p, n;
    electrical p, n;
    real x;
    integer x;
    analog I(p, n) <+ V(p, n);
endmodule
