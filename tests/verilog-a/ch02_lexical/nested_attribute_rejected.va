// LRM 2.9: "Nesting of attribute instances is disallowed. It shall be illegal
// to specify the value of an attribute with a constant expression that
// contains an attribute instance." Below, the value of `outer` is the constant
// expression `1 + (* inner *) 2`, which contains an attribute instance -- the
// second sentence, exactly.
//
// The outer attribute sits in a slot the grammar really has, so the nesting is
// the ONLY thing wrong with the file: Syntax 2-7 spells `non_port_module_item
// ::= ... | { attribute_instance } parameter_declaration ;`. That placement is
// load-bearing. Written with the outer attribute at a PRIMARY position instead
// -- `analog I(p) <+ ((* outer = ... *) x) * V(p);` -- the parser dies on the
// OUTER `(*`, because no grammar slot exists there; that is illegal placement,
// already owned by attribute_illegal_placement_rejected.va, and deleting the
// inner attribute leaves such a file rejected byte-identically, so it pins
// nothing about nesting at all. Delete `(* inner *)` from THIS file and it
// compiles clean, which is what makes the nesting the cause of the diagnostic.
//
// It used to arrive as E0205: the nested `(*` desynchronized a token-scanning
// attribute skip, so the module item ended where the parser did not expect one —
// the right verdict for no reason at all. The parser now reads an attribute value
// as an expression and refuses a second instance inside one, so the code is
// E0357, the clause's own rule. The legal cases this bounds -- a value-less attribute
// defaulting to 1, and several attribute instances in a row -- are in
// attribute_default_and_multiple.va, and 53_attribute_value_not_constant.va
// is the other half of the same sentence pair.
//! lrm 2.9
//! lrm 2.9:5
//! lrm 2.9.1
//! reject-only E0357
//! neighbour attribute_default_and_multiple.va
`include "disciplines.vams"
module ch2_nested_attr(p);
    inout p;
    electrical p;
    (* outer = (1 + (* inner *) 2) *) parameter real x = 1.0;
    analog I(p) <+ x * V(p);
endmodule
