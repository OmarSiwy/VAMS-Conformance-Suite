// LRM 2.9 enumerates where an attribute_instance may appear, and the list is
// closed: "An attribute_instance can appear in the Verilog-AMS description as a
// prefix attached to a declaration, a module item, a statement, or a port
// connection. It can appear as a suffix to an operator or a Verilog-AMS
// function name in an expression."
//
// Syntax 2-5 through 2-10 then place the `{ attribute_instance }` slots
// exactly, and for a parameter there is one slot only:
//
//     non_port_module_item ::= ... | { attribute_instance } parameter_declaration ;
//
// The slot is BEFORE the whole declaration. Between the type keyword and the
// declared identifier there is no slot at all, so `parameter real (* q *) x`
// has the attribute in a position the grammar does not admit.
//
// This is the bound on the two fixtures that widen where VerA accepts
// attributes — function_call_attribute.va (suffix to a function name, an
// LRM Example 7 that VerA cannot parse yet) and operator_attribute.va
// (suffix to an operator, Example 6). Both fixes add a `{ attribute_instance }`
// slot to the parser. This file is the negative that says how far they go: a
// parser that answers them by accepting `(*` wherever it appears will start
// failing here, loudly, which is the point.
//! lrm 2.9
//! lrm 2.9:2
//! lrm 2.9.1
//! lrm 2.9.1:1000
//! reject-only E0208
//! neighbour operator_attribute.va
//! neighbour function_call_attribute.va
`include "disciplines.vams"
module ch02_attribute_illegal_placement_rejected(p, n);
    inout p, n;
    electrical p, n;
    parameter real (* q *) gain = 1.0;
    analog I(p, n) <+ gain * V(p, n);
endmodule
