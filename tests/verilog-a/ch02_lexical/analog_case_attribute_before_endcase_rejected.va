// §2.9: "An attribute_instance can appear in the Verilog-AMS description as a
// prefix attached to a declaration, a module item, a statement, or a port
// connection." A.6.7: `analog_case_statement ::= case ( analog_expression )
// analog_case_item { analog_case_item } endcase` with `analog_case_item ::=
// analog_expression { , analog_expression } : analog_statement_or_null |
// default [ : ] analog_statement_or_null`: an instance may prefix an item's
// statement, and no production puts one before `endcase`.
//
// The `(* a *)` below comes after the last case item and right before
// `endcase`: nothing follows it for it to prefix. That is E0207 ("an
// attribute instance prefixes nothing"), the code the same instance gets
// before the `end` of an analog block
// (analog_block_attribute_before_end_rejected.va). Before #69 the arm loop
// took it for the start of a case item and refused `endcase` as E0209
// "expected an expression". Nothing else in the source is wrong, so E0207 is
// the only error.
//
// Legal neighbour: analog_case_item_statement_attribute.va, whose case items
// have the same instance prefixing their statements.
//
//! lrm 2.9
//! reject-only E0207
//! neighbour analog_case_item_statement_attribute.va
`include "disciplines.vams"
module ch2_case_attr_before_endcase(p);
  inout p; electrical p;
  integer k;
  analog begin
    k = 2;
    case (k)
      1: I(p) <+ V(p);
      default: I(p) <+ 2 * V(p);
      (* a *)
    endcase
  end
endmodule
