// LRM 2.9.2, op: its value must be either "yes" or "no".
// Integer 1 is neither string. This is independent of 52's invalid string
// "maybe": accepting numeric truth values also violates the stated domain.
//! lrm 2.9.2
//! lrm 2.9.2:3
//! reject-only E0358
`include "disciplines.vams"
module ch02_op_attribute_numeric_rejected(p, n);
    inout p, n;
    electrical p, n;
    (* op = 1 *) parameter real gain = 1.0;
    analog I(p, n) <+ gain * V(p, n);
endmodule
