// §2.9: "An attribute_instance can appear in the Verilog-AMS description as a
// prefix attached to a declaration, a module item, a statement, or a port
// connection." A.6.3: `analog_seq_block ::= begin [ : analog_block_identifier
// { analog_block_item_declaration } ] { analog_statement } end`, and A.6.4
// puts `{ attribute_instance }` before each analog_statement.
//
// The block below closes properly, but its `(* a *)` comes after the block's
// only statement and right before `end`: nothing follows it for it to prefix.
// That is E0207 ("an attribute instance prefixes nothing"), the code the same
// instance gets before the `end` of a generate block
// (ch06_hierarchy/generate_block_attribute_before_end_rejected.va) or before
// `endmodule`. Before #66 the statement loop took it for the start of a
// statement and refused `end` as E0209 "expected an expression". Nothing else
// in the source is wrong, so E0207 is the only error.
//
// Legal neighbour: analog_statement_attributes.va, whose analog block has
// instances prefixing each of its statements.
//
//! lrm 2.9
//! reject-only E0207
//! neighbour analog_statement_attributes.va
`include "disciplines.vams"
module ch2_block_attr_before_end(p);
  inout p; electrical p;
  analog begin I(p) <+ V(p); (* a *) end
endmodule
