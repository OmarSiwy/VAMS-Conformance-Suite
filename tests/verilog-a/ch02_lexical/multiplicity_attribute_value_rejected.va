// LRM 2.9.2 requires multiplicity to be "multiply", "divide", or "none".
// "sideways" is a string outside that enumeration. This fixture contains
// no sibling violation that could mask a missing multiplicity check.
//! lrm 2.9.2
//! lrm 2.9.2:4
//! reject-only E0358
//! neighbour standard_attributes_on_declarations.va
`include "disciplines.vams"
module ch02_multiplicity_attribute_value_rejected(p, n);
    inout p, n;
    electrical p, n;
    (* multiplicity = "sideways" *) parameter real gain = 1.0;
    analog I(p, n) <+ gain * V(p, n);
endmodule
