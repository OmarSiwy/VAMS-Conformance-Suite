// LRM 2.6.2: "Real numbers expressed with a decimal point shall have at least
// one digit on each side of the decimal point", and `.12` is the FIRST entry in
// the list that follows — "The following are invalid forms of real numbers
// because they do not have at least one digit on each side of the decimal
// point: .12  9.  4.E3  .2e-7  .1p  34.M".
//
// So the rejection is normative, not a VerA quirk: this file is named
// `_rejected` for the same reason 15/16/43/44/45 are, and together the six
// cover the whole list.
//! lrm 2.6.2
//! lrm 2.6.2:2
//! reject-only E0209
`include "disciplines.vams"
module ch02_real_leading_dot_rejected(p, n);
    inout p, n;
    electrical p, n;
    analog I(p, n) <+ .12;
endmodule
