// IEEE 1364-2005 §19.4 Syntax 19-5 (taken whole by §10.1):
//
//     { `elsif text_macro_identifier elsif_group_of_lines }
//
// `elsif tests a macro name exactly as `ifdef does: "the compiler checks for
// the definition of the text_macro_name". A bare `elsif is not `else.
//
//! lrm 10.1
//! inherited IEEE 1364-2005 19.4
//! reject-only E0107
`include "disciplines.vams"
`ifdef CH10_NEVER_DEFINED
`elsif
`endif
module ch10_elsif_requires_a_name(p, n);
  inout p, n; electrical p, n;
  analog I(p, n) <+ V(p, n);
endmodule
