// §10.1: "All Verilog-AMS HDL compiler directives are preceded by the ( ` )
// character." The only other use of the accent grave is a macro use, IEEE
// 1364-2005 §19.3.1 Syntax 19-3:
//
//     text_macro_usage ::= `text_macro_identifier [ ( list_of_actual_arguments ) ]
//
// Both productions put a NAME directly after the accent. Below, a space
// separates the accent from `define`, so the line is neither a directive nor a
// macro use and has no derivation. A tool that skipped the blank would read a
// `define the writer did not type; one that dropped the accent would leave
// `define B 2` as stray source text.
//
// The legal spelling, `define with no gap, is define_object.va.
//
//! lrm 10.1
//! inherited IEEE 1364-2005 19.3.1
//! reject-only E0103
//! neighbour define_object.va
`include "disciplines.vams"
` define B 2
module ch10_grave_accent_needs_a_name(p, n);
  inout p, n; electrical p, n;
  analog I(p, n) <+ V(p, n);
endmodule
