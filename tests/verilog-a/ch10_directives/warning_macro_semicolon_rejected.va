// A.6.4: an `analog_seq_block` (A.6.3) is `{ analog_statement }`, and no
// `analog_statement` alternative is `;`. The null exists only in
//
//     analog_statement_or_null ::= analog_statement
//                                | { attribute_instance } ;              // A.6.4
//
// which a conditional arm, a case item and an event statement reach. So the
// empty statement is legal in those places and nowhere else in a sequential
// block (annex_g_change_history/null_statement_unconditional_rejected.va
// is the same refusal written out as a bare `;`).
//
// This is that rule under a macro, which is how CMC's
// macrosAndDefines_cmc.va meets it:
//
//     `define WARNING(str) $strobe(str);
//
// The body carries its own `;`, and every CMC call site adds another:
//
//     `WARNING("...");   ->   $strobe("...");;
//
// The first `;` terminates the system-task statement; the second has no
// statement to terminate and is a null in an `analog_seq_block` — E0219.
// TRIAGE: cmcqa/r[23]/compile/vera and vampyre's cmcqa/r[23]/compile. The
// corrected R3_CMC 1.1.2 drops the call site's `;` and compiles; that legal
// use is the neighbour.
//
//! lrm 10.4
//! lrm A.6.4
//! lrm A.6.3
//! lrm G.2.2
//! reject-only E0219
//! neighbour warning_macro_statement_use.va
`include "disciplines.vams"
`define WARNING(str) $strobe(str);
module ch10_triage_warning_macro_semicolon_rejected(p, n);
  inout p, n; electrical p, n;
  analog begin
    `WARNING("the macro ends with a semicolon of its own");
    I(p, n) <+ V(p, n);
  end
endmodule
