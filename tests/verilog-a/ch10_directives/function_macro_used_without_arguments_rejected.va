// IEEE 1364-2005 §19.3.1 (the macro-use rules §10.4 defers to): "To use a macro
// defined with arguments, the name of the text macro shall be followed by a
// list of actual arguments in parentheses, separated by commas." And: "The
// number of actual arguments shall match the number of formal arguments."
//
// SQ takes one argument, and the use below has no argument list at all. It is
// not a shorthand for the body with the formal left in place.
//
// The legal use is define_function.va; wrong-count uses are
// macro_too_few_actuals_rejected.va and macro_too_many_actuals_rejected.va.
//
//! lrm 10.4
//! inherited IEEE 1364-2005 19.3.1
//! reject-only E0116
//! neighbour define_function.va
`include "disciplines.vams"
`define SQ(x) ((x)*(x))
module ch10_function_macro_used_without_arguments(p, n);
  inout p, n; electrical p, n;
  analog I(p, n) <+ `SQ * V(p, n);
endmodule
