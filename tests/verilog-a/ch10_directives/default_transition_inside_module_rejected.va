// §10.3: "The scope of this directive is similar to the scope of the `define
// compiler directive although it can be used only outside of module
// definitions." The very next sentence, "There are no scope restrictions for
// this directive", is about the transition filters that follow; the directive
// itself is outside-module only.
//
// default_transition.va is the legal form: the same directive at file scope,
// before any module, and every transition filter after it takes the value.
// Here it stands inside the module body, where no module item derives it.
//
//! lrm 10.3
//! lrm 10.3:1001
//! reject-only E0202
//! neighbour default_transition.va
`include "disciplines.vams"
module ch10_default_transition_inside_module(p, n);
  inout p, n; electrical p, n;
  `default_transition 1n
  analog I(p, n) <+ V(p, n);
endmodule
