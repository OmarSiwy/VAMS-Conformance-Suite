// 52's rule on the other kind of undeclared name: one that appears in
// BEHAVIORAL code rather than as an instance terminal.
//
// §3.6.5 words its licence as "nets can be used in structural descriptions
// without being declared", so this shape is not the clause's printed case. It
// is still an undeclared identifier used as a net — `V(p, floating)` names two
// nodes, and §1.3.1 makes the branch potential their difference, so the second
// operand has to be one — and VerA answers it with the same implicit net the
// structural case gets. E0337 then reports the consequence ("net has no
// discipline") whenever no §10.2 default supplies one.
//
// IEEE 1364 §19.2's `none` withdraws the implicit net, and therefore this too:
// there is no wire for the probe to read, so the mistyped name is refused where
// it is written instead of three phases later and under a different code.
//
// The two files are worth writing separately because they are two code paths
// and only one of them can be reached from the other's shape: 52's name never
// appears in an expression, and this one's never appears on an instance.
//
//! lrm 10.1
//! lrm 3.6.5
//! reject-only E0367
`include "disciplines.vams"
`default_nettype none
module ch10_default_nettype_none_rejects_an_undeclared_probe(p);
    inout p;
    electrical p;

    analog I(p) <+ 0.001 * V(p, floating);
endmodule
