// §10.6: the `begin_keywords directive affects the source "until the matching
// `end_keywords directive is encountered." Nothing in the suite observed what
// happens AFTER that point — 16, 25 and 26 each wrap their only module in the
// pair, so the file ends immediately after `end_keywords and a completely
// no-op `end_keywords passes all three.
//
// This is the discriminator, and the word that carries it is "matching": the
// directives nest, so closing the inner pair must put back the set the OUTER
// one selected, not merely stop applying the inner one.
//
// The outer `begin_keywords "VAMS-2023" is the point of the file's shape and
// not decoration. §10.6 says of a module with no directive before it that "the
// set of reserved keywords in effect for this module shall be the
// implementation's default set of reserved keywords", and its own worked
// example is conditional in exactly the same way — the 1364-2005 directive
// "would be necessary in this example IF an implementation uses Verilog-AMS as
// its default set of keywords". So a bare `end_keywords followed by a module
// pins nothing: a conforming tool whose default set is 1364-2005 compiles that
// module, and a fixture demanding a diagnostic there would be testing one
// implementation's choice of default rather than the LRM. Naming "VAMS-2023"
// explicitly on the outside removes the choice — after the inner
// `end_keywords the set in force is the one this file asked for, and under it
// §10.6 says: 'ERROR: "sin" is a keyword in Verilog-AMS'.
//
// Inner module: the §10.6 worked example itself, `sin` as a port name under
// "1364-2005", which must parse. Outer module: the same text after the pair
// closes, which must not. A tool that never restores the set compiles both.
//
// Like 16, 25 and 26, the inner module writes `analog` inside a "1364-2005"
// region, which is only legal under §10.6's "The directives ... do not affect
// the semantics, tokens, and other aspects of the Verilog-AMS language" — see
// the note in 16. The rejection demanded below is on the OUTER module, where
// VAMS-2023 is in force, so that reading changes nothing about the verdict.
//
//! lrm 10.6
//! lrm 10.6:1002
//! reject-only E0208
//! neighbour begin_keywords_verilog.va
`include "disciplines.vams"
`begin_keywords "VAMS-2023"
`begin_keywords "1364-2005"
module ch10_end_keywords_inner(sin, n);
  inout sin, n;
  electrical sin, n;
  analog I(sin, n) <+ V(sin, n);
endmodule
`end_keywords
module ch10_end_keywords_restores_previous_set(sin, n); // ERROR: sin is reserved again
  inout sin, n;
  electrical sin, n;
  analog I(sin, n) <+ V(sin, n);
endmodule
`end_keywords
