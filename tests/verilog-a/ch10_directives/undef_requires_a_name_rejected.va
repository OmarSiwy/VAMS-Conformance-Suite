// §10.4 defers `undef to IEEE Std 1364. IEEE 1364-2005 §19.3.2 Syntax 19-4:
//
//     undefine_compiler_directive ::= `undef text_macro_identifier
//
// The directive "shall undefine a previously defined text macro", so it needs
// the macro's name. The legal form is undef_conditional.va.
//
//! lrm 10.4
//! inherited IEEE 1364-2005 19.3.2
//! reject-only E0113
//! neighbour undef_conditional.va
`include "disciplines.vams"
`define CH10_GAIN 1.0
`undef
module ch10_undef_requires_a_name(p, n);
  inout p, n; electrical p, n;
  analog I(p, n) <+ V(p, n);
endmodule
