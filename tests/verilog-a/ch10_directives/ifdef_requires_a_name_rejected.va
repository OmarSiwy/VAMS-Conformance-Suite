// IEEE 1364-2005 §19.4 Syntax 19-5 (taken whole by §10.1):
//
//     ifdef_directive ::= `ifdef text_macro_identifier ...
//
// The macro name is not optional: `ifdef "checks for the definition of a
// text_macro_name", and there is nothing to check here.
//
//! lrm 10.1
//! inherited IEEE 1364-2005 19.4
//! reject-only E0104
`include "disciplines.vams"
`ifdef
`endif
module ch10_ifdef_requires_a_name(p, n);
  inout p, n; electrical p, n;
  analog I(p, n) <+ V(p, n);
endmodule
