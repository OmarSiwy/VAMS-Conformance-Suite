// §10.6 requires the older Verilog-AMS keyword list to be selectable too: "The
// version specifiers "1364-1995", "1364-2001", "1364-2005" and "VAMS-2.3" must
// also be supported. ... "VAMS-2.3" represents the keywords for Verilog-AMS 2.3
// HDL." sin is a reserved word in Verilog-AMS 2.3 as it is in 2023 (Annex B),
// so the chapter's "shall result in an error" example holds under this
// specifier exactly as it does under "VAMS-2023" in 17.
//
// The pair matters: a front end that recognises the string "VAMS-2.3" but maps
// it to a Verilog keyword list — the easy mistake, since the other three
// accepted spellings ARE Verilog lists — compiles this file and still passes 17.
//
// The expectation is the stable code, not the bare substring "sin", which any
// diagnostic containing those three letters satisfies — including one about
// this file's own module name.
//
//! lrm 10.6
//! reject-only E0208
//! neighbour begin_keywords_vams_2_3_accepted.va
`include "disciplines.vams"
`begin_keywords "VAMS-2.3"
module ch10_begin_keywords_vams_2_3(sin, n);
  inout sin, n; electrical sin, n;
  analog I(sin,n) <+ V(sin,n);
endmodule
`end_keywords
