// The refusal neighbour of include_verilog_a_1_0_header_names.va
// (specification/Vague_Decisions.md VD-093): only the Annex D names and their two
// Verilog-A 1.0 spellings are built in. "disciplines.h" is neither, exists
// on no search path, and so is E0126.
//! lrm 10.1
//! inherited IEEE 1364-2005 19.5
//! reject-only E0126
//! neighbour include_verilog_a_1_0_header_names.va
`include "disciplines.vams"
`include "disciplines.h"
module include_unknown_header_name_rejected(p, n);
  inout p, n; electrical p, n;
  analog I(p, n) <+ V(p, n);
endmodule
