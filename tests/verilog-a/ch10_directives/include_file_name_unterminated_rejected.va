// IEEE 1364-2005 §19.5 Syntax 19-6 (taken whole by §10.1):
//
//     include_compiler_directive ::= `include "filename"
//
// and "Only white space or a comment may appear on the same line as the
// `include compiler directive." The closing quote is missing, so the file name
// runs to the end of the line and no complete directive is there to read.
//
//! lrm 10.1
//! inherited IEEE 1364-2005 19.5
//! reject-only E0123
`include "disciplines.vams"
`include "disciplines.vams
module ch10_include_file_name_unterminated(p, n);
  inout p, n; electrical p, n;
  analog I(p, n) <+ V(p, n);
endmodule
