// §10.1 takes `else and `elsif from IEEE Std 1364. IEEE 1364-2005 §19.4
// Syntax 19-5 reaches `else only inside an ifdef_directive or ifndef_directive:
//
//     ifdef_directive ::= `ifdef text_macro_identifier ifdef_group_of_lines
//                         { `elsif text_macro_identifier elsif_group_of_lines }
//                         [ `else else_group_of_lines ] `endif
//
// and of `elsif the clause says outright: "This directive shall be preceded by
// an `ifdef or `ifndef directive."
//
// Here no conditional is open, so the `else has nothing to be the alternative
// of. The legal shape is ifdef_else.va.
//
//! lrm 10.1
//! inherited IEEE 1364-2005 19.4
//! reject-only E0105
//! neighbour ifdef_else.va
`include "disciplines.vams"
`else
module ch10_else_without_ifdef(p, n);
  inout p, n; electrical p, n;
  analog I(p, n) <+ V(p, n);
endmodule
