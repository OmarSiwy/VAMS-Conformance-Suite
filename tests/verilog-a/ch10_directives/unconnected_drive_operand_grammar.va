// IEEE Std 1364 §19.9, carried over by §10.1 Table 10-1, writes the directive
// as a two-way alternation with no brackets round the operand:
//
//     `unconnected_drive pull1 | pull0
//
// So a bare `` `unconnected_drive `` is not "go back to the default" — that is
// `` `nounconnected_drive ``, which Table 10-1 lists as a SEPARATE directive
// with its own row. This file writes the bare form, which is therefore a
// directive with its operand missing.
//
// Worth a fixture because the bare form is exactly what a tool that
// accepts-and-ignores the family produces no complaint about, and because the
// reading it invites — "no operand means stop pulling" — is available, wrong,
// and silently changes what an unconnected input does (58 against 60).
//
// The module is 16's one-resistor body, so the directive is the only thing
// under test.
//
//! lrm 10.1
//! inherited IEEE 1364-2005 19.9
//! reject-only E0141
`include "disciplines.vams"
`unconnected_drive
module ch10_unconnected_drive_operand_grammar(p, n);
    inout p, n;
    electrical p, n;
    analog I(p, n) <+ V(p, n);
endmodule
`nounconnected_drive
