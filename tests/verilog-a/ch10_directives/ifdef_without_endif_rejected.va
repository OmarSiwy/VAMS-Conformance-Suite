// IEEE 1364-2005 §19.4 Syntax 19-5 (taken whole by §10.1) closes every
// conditional with a mandatory `endif:
//
//     ifdef_directive ::= `ifdef text_macro_identifier ifdef_group_of_lines
//                         { `elsif ... } [ `else else_group_of_lines ] `endif
//
// The `ifdef below is never closed. The macro is undefined, so a tool that let
// the block close silently at end of file would also discard the module and
// report something unrelated, or nothing.
//
//! lrm 10.1
//! inherited IEEE 1364-2005 19.4
//! reject-only E0101
`include "disciplines.vams"
`ifdef CH10_NEVER_DEFINED
module ch10_ifdef_without_endif(p, n);
  inout p, n; electrical p, n;
  analog I(p, n) <+ V(p, n);
endmodule
