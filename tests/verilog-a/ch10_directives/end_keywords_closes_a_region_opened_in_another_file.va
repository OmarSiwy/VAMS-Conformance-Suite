// The closing half of 02, and the only rejection this row writes.
//
// §10.6: "until the MATCHING `end_keywords directive is encountered." 02 shows
// that a region opened in an included file stays open past the end of that
// file. This shows that it is nonetheless CLOSED by an `end_keywords in a
// different file from its `begin_keywords, and that closing it restores the
// enclosing region rather than the implementation's default set.
//
// The file is three regions deep by design:
//
//   `begin_keywords "VAMS-2023"          <- opened here
//     `include ...                       <- opens "1364-2005" in another file
//     module d10_..._inner(sin, n)       <- MUST compile: 1364-2005 in force
//   `end_keywords                        <- closes the INCLUDE's region
//   module d10_..._outer(sin, n)         <- MUST NOT compile: VAMS-2023 again
//   `end_keywords
//
// The inner module is §10.6's own worked example ("input sin; // OK since sin
// is not a keyword in 1364-2005"), so a tool that refuses it is over-strict and
// fails this file for the opposite reason. The outer module is the clause's
// next example verbatim — "module m2 (sin, ... ); // ERROR: "sin" is a keyword
// in Verilog-AMS" — which is where the demanded diagnostic comes from.
//
// WHAT FAILS IT, and why each failure mode is distinct from every fixture that
// already exists:
//   - a tool that pops the keyword set at end-of-include has the inner module
//     parsed under VAMS-2023 and rejects the WRONG module (02's failure mode,
//     restated so a fix that only patches 02 cannot pass both);
//   - a tool whose `end_keywords cannot close a region opened in another file
//     either refuses the directive outright or leaves 1364-2005 in force, in
//     which case the outer module compiles and this file is green when it must
//     be red. ch10_directives/33 is the one-file version of exactly this and is
//     satisfied by a stack that never crosses a boundary.
//
// E0208 is the code VerA prints for "expected an identifier: found `sin`",
// which is the diagnostic the clause's ERROR comment describes; §10.6 itself
// states no code, only "shall result in an error".
//
//! lrm 10.6
//! lrm 10.6:1002
//! lrm 10.1
//! reject-only E0208
//! neighbour begin_keywords_region_survives_the_include_that_opened_it.va
`include "disciplines.vams"
`begin_keywords "VAMS-2023"
`include "d10_keywords_1364_2005.vh"
module d10_end_keywords_cross_file_inner(sin, n); // OK: 1364-2005 is in force
  inout sin, n;
  electrical sin, n;
  analog I(sin, n) <+ V(sin, n);
endmodule
`end_keywords
module d10_end_keywords_cross_file_outer(sin, n); // ERROR: "sin" is a keyword again
  inout sin, n;
  electrical sin, n;
  analog I(sin, n) <+ V(sin, n);
endmodule
`end_keywords
