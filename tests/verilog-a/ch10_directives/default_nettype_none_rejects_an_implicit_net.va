// §10.1 Table 10-1 carries `default_nettype over from IEEE Std 1364 unchanged,
// and 1364 §19.2 gives the `none` operand its whole meaning: with it in force
// there is no type for an implicit net to HAVE, so an undeclared identifier
// used as a net is an error rather than a silently created wire.
//
// What it withdraws is §3.6.5: "Nets can be used in structural descriptions
// without being declared. In this case, the net's discipline and domain binding
// will be determined by discipline resolution." `link` below is exactly that —
// written once, as an actual on an instance, and declared nowhere — which makes
// this file ch03_data_types/implicit_nets.va with one directive added and
// the opposite verdict.
//
// THE SHAPE IS THE STRUCTURAL ONE ON PURPOSE. §3.6.5's sentence says "in
// structural descriptions", so the instance terminal is the case the clause is
// about and the case a tool has to get right; 53 pins the other half, a
// behavioral reference to a name nobody declared, which VerA treats by the same
// rule.
//
// WHY THIS IS WORTH A DIRECTIVE AT ALL. Without it a mistyped terminal is not a
// diagnostic, it is a new floating node — the design elaborates, simulates, and
// is wrong in a way no message points at. That is the mistake `none` exists to
// convert into this one.
//
//! lrm 10.1
//! lrm 3.6.5
//! reject-only E0367
//! neighbour ../ch03_data_types/implicit_nets.va
`include "disciplines.vams"
`default_nettype none
module ch10_nettype_none_child(a, b);
    inout a, b;
    electrical a, b;
    analog I(a, b) <+ 0.001 * V(a, b);
endmodule

module ch10_default_nettype_none_rejects_an_implicit_net(p);
    inout p;
    electrical p;

    ch10_nettype_none_child u(p, link);

    analog I(p) <+ 0.0;
endmodule
