// IEEE 1364-2005 §19.3.1 Syntax 19-2 (the `define grammar §10.4 defers to):
//
//     list_of_formal_arguments ::= formal_argument_identifier { , formal_argument_identifier }
//
// and "The formal argument names shall be simple_identifiers, separated by
// commas and optionally whitespace." The two formals below are separated by
// whitespace only.
//
// The legal two-formal definition is define_function.va.
//
//! lrm 10.4
//! inherited IEEE 1364-2005 19.3.1
//! reject-only E0112
//! neighbour define_function.va
`include "disciplines.vams"
`define MUL(a b) ((a)*(b))
module ch10_define_formals_need_commas(p, n);
  inout p, n; electrical p, n;
  analog I(p, n) <+ V(p, n);
endmodule
