// IEEE 1364-2005 §19.4 (taken whole by §10.1), of `elsif: "This directive
// shall be preceded by an `ifdef or `ifndef directive."
//
// No conditional is open when the `elsif below is read. The legal shape, an
// `elsif inside an `ifdef block, is elsif.va.
//
//! lrm 10.1
//! inherited IEEE 1364-2005 19.4
//! reject-only E0105
//! neighbour elsif.va
`include "disciplines.vams"
`elsif SOMETHING
`endif
module ch10_elsif_without_ifdef(p, n);
  inout p, n; electrical p, n;
  analog I(p, n) <+ V(p, n);
endmodule
