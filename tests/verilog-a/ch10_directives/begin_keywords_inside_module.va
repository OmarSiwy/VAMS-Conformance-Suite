// §10.6, the chapter's strongest prohibition: "The `begin_keywords and
// `end_keywords directives can only be specified outside of a design element
// (module, primitive, configuration, paramset, connectrules or connectmodule)."
//
// Every other keyword-set fixture (16, 25, 26, 27, 17) uses the legal placement,
// so a front end that simply ignores where the directive sits passes all of
// them. This one puts the directive between the net declarations and the analog
// block of a module — inside a design element by any reading — and the whole
// point of the rule is that the reserved-word set may not change part-way
// through parsing one.
//
// The specifier itself is a legal one ("1364-2005", §10.6), so the only thing
// wrong with the file is the placement.
//
// The `analog` that follows the misplaced directive rests on the same reading
// of §10.6 as 16 does — see the note there. It is only there so the module is
// a complete design element; the diagnostic demanded is on the directive, one
// line earlier.
//
//! lrm 10.6
//! lrm 10.6:1001
//! reject-only E0202
//! neighbour begin_keywords_verilog.va
`include "disciplines.vams"
module ch10_begin_keywords_inside_module(p, n);
  inout p, n;
  electrical p, n;
`begin_keywords "1364-2005"
  analog I(p, n) <+ V(p, n);
`end_keywords
endmodule
