// §10.1's scope sentence has three clauses and 55 pins only one of them. The
// middle one is this file's subject:
//
//     "The scope of compiler directives extends from the point where it is
//      processed, ACROSS ALL FILES PROCESSED, to the point where another
//      compiler directive supersedes it or the processing completes."
//
// A directive is therefore not scoped to the file it is written in. The only
// file boundary a one-file-per-invocation suite can put inside a compilation is
// an `include, so `nettype_none.vh` carries the directive and nothing else, and
// the module that breaks it is here — on the other side of the boundary and
// after the header has been closed.
//
// A tool that resets `default_nettype at end-of-include compiles this file, and
// nothing else in the suite would catch that: 52 and 53 both write the
// directive and the offending net into ONE file, so they are green under either
// reading. That is the whole reason this one exists.
//
// The same sentence runs the other way for `begin_keywords, and 31's header
// spells that half out: a directive left open at end of file is the clause
// working, not an error.
//
//! lrm 10.1
//! lrm 3.6.5
//! lrm 2.8.4
//! lrm 2.8.4:2
//! lrm 10.1:1000
//! reject-only E0367
//! neighbour ../../verilog-ams/ch10_directives/default_nettype_wire_restores_implicit_nets.va
`include "disciplines.vams"
`include "nettype_none.vh"
module ch10_crosses_boundary_child(a, b);
    inout a, b;
    electrical a, b;
    analog I(a, b) <+ 0.001 * V(a, b);
endmodule

module ch10_default_nettype_crosses_a_file_boundary(p);
    inout p;
    electrical p;

    ch10_crosses_boundary_child u(p, link);

    analog I(p) <+ 0.0;
endmodule
