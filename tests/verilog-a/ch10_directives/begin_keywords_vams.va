// §10.6's own worked example, and the only place the chapter says "shall
// result in an error":
//
//   `begin_keywords "VAMS-2023" // use Verilog-AMS LRM 2023 keywords
//   module m2 (sin, ... );      // ERROR: "sin" is a keyword in Verilog-AMS
//
// "The version_specifier, "VAMS-2023" specifies that only the identifiers
// listed as reserved keywords in the Verilog-AMS HDL are considered to be
// reserved words. These identifiers are listed in Annex B." sin is in Annex B,
// so under this keyword set it cannot be a port name. 16/25/26 are the same
// source under "1364-2005"/"1364-1995"/"1364-2001", where §10.6 says it is
// legal and it must compile; the contrast between those and this file is the
// whole rule.
//
// The expectation is the stable code, not the bare substring "sin", which any
// diagnostic containing those three letters satisfies — including one about
// this file's own module name.
//
//! lrm 10.6
//! lrm 10.6:3
//! reject-only E0208
//! neighbour begin_keywords_verilog.va
`include "disciplines.vams"
`begin_keywords "VAMS-2023"
module ch10_begin_keywords_vams(sin, n);
  inout sin, n; electrical sin, n;
  analog I(sin,n) <+ V(sin,n);
endmodule
`end_keywords
