// IEEE 1364-2005 §19.5 (VAMS §10.1); VerA's search order is
// specification/Vague_Decisions.md VD-091: the including file's directory, then -I.
//
// "The including file's directory" is per file, not a path that grows as
// files are included: vd091_nested_only.vh is in include_dir/, and this file is
// in ch10_directives/. Neither this directory nor the runner's -I paths
// (tests/fixtures, tests/fixtures/ch10_directives) holds it, so there are no
// contents to insert. The same name included from include_dir/vd091_outer.vh
// is found: include_searches_the_including_files_directory.va, the legal
// neighbour, differs only in naming include_dir/vd091_outer.vh instead.
//! lrm 10.1
//! inherited IEEE 1364-2005 19.5
//! reject-only E0126
//! reject "vd091_nested_only.vh"
//! neighbour include_searches_the_including_files_directory.va
`include "disciplines.vams"
`include "vd091_nested_only.vh"
module include_including_dir_is_per_file_rejected(p, n);
  inout p, n; electrical p, n;
  analog I(p, n) <+ V(p, n);
endmodule
