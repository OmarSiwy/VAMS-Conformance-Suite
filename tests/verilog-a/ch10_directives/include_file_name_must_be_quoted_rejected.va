// §10.1 takes `include from IEEE Std 1364. IEEE 1364-2005 §19.5 Syntax 19-6:
//
//     include_compiler_directive ::= `include "filename"
//
// The quotes are part of the production. A bare word is not a file name here,
// even one that names a file the tool could find.
//
//! lrm 10.1
//! inherited IEEE 1364-2005 19.5
//! reject-only E0122
`include "disciplines.vams"
`include disciplines.vams
module ch10_include_file_name_must_be_quoted(p, n);
  inout p, n; electrical p, n;
  analog I(p, n) <+ V(p, n);
endmodule
