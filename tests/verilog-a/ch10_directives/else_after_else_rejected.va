// IEEE 1364-2005 §19.4 Syntax 19-5 (taken whole by §10.1):
//
//     ifdef_directive ::= `ifdef text_macro_identifier ifdef_group_of_lines
//                         { `elsif text_macro_identifier elsif_group_of_lines }
//                         [ `else else_group_of_lines ] `endif
//
// At most one `else, and it is the last arm: every `elsif precedes it. The
// block below has an `elsif AFTER its `else, which the production cannot
// derive. (A second `else is the same error; one case is enough to pin it.)
//
//! lrm 10.1
//! inherited IEEE 1364-2005 19.4
//! reject-only E0106
`include "disciplines.vams"
`ifdef CH10_NEVER_DEFINED
`else
`elsif CH10_ALSO_UNDEFINED
`endif
module ch10_else_after_else(p, n);
  inout p, n; electrical p, n;
  analog I(p, n) <+ V(p, n);
endmodule
