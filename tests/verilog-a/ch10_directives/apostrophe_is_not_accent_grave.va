// §10.1 spends two sentences separating one character from another: "All
// Verilog-AMS HDL compiler directives are preceded by the ( ` ) character. This
// character is called accent grave (ASCII 0x60). It is different from the
// character ( ' ), which is the apostrophe character (ASCII 0x27)."
//
// The distinction is load-bearing because the apostrophe already has a job in
// this language — §2.6 gives it the base marker of a sized literal, 8'hAf — so
// a lexer that treats the two interchangeably does not merely mis-handle a
// directive, it makes 'define ambiguous with a malformed based literal.
//
// Every other fixture in this chapter writes the correct character, so nothing
// caught a front end that accepted the wrong one. The line below is the one
// character away from 04's legal `define GAIN 3.0.
//
// What is pinned is only that the file does not compile — i.e. that GAIN is not
// silently defined by an apostrophe directive. Which diagnostic a conforming
// tool reports is its own business (§10.1 states no code and no wording); VerA's
// is E0201 "construct is not in the supported subset: `invalid token`", raised
// at the apostrophe itself.
//
//! lrm 10.1
//! lrm 10.1:1000
//! reject-only E0201
//! neighbour define_object.va
`include "disciplines.vams"
'define GAIN 3.0
module ch10_apostrophe_is_not_accent_grave(p, n);
  inout p, n; electrical p, n;
  analog I(p,n) <+ V(p,n);
endmodule
