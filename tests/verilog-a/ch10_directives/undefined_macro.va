// §10.4 hands `define and `undef to IEEE Std 1364, whose §19.3.1 makes the use
// of a text macro that was never defined illegal — there is no text to
// substitute, so the token stream the parser is handed has a hole in it.
//
// The expectation is the stable code and not the phase label ParseError, which
// any parse-phase failure satisfies: a typo'd keyword three lines down would
// pass the old form of this fixture while the macro rule went untested.
//
//! lrm 10.4
//! reject-only E0115
`include "disciplines.vams"
module ch10_undefined_macro(p, n);
  inout p, n; electrical p, n;
  analog I(p,n) <+ `MISSING*V(p,n);
endmodule
