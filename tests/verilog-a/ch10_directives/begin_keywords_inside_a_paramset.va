// §10.6 names the elements its placement rule covers, and there are six of
// them: "The `begin_keywords and `end_keywords directives can only be specified
// outside of a design element (module, primitive, configuration, paramset,
// connectrules or connectmodule)."
//
// 29 pins the module. This pins the `paramset`, which is a design element in
// the same list and in A.1.2's same `description` production — §6.4 makes one
// instantiable "exactly like a module", so it is a unit that gets PARSED, and a
// keyword set that changed halfway through parsing one is the same defect the
// clause forbids in a module.
//
// This file used to be accepted-adjacent in the weak sense that it was refused
// by the wrong rule: the directive fell through the paramset item grammar and
// came out as E0205, "unsupported module item", which says A.1.9 has no such
// production. True, and not the reason. The reason is §10.6.
//
// The paramset is otherwise a working one — 6.4's own shape, a target module
// and one `.parameter = value;` statement — so the directive is the only thing
// under test.
//
// A.1.9: a paramset needs >= 1 paramset_item_declaration (corrected 2026-10-08)
//! lrm 10.6
//! lrm 10.6:1001
//! reject-only E0202
//! neighbour begin_keywords_verilog.va
`include "disciplines.vams"
module ch10_keywords_paramset_target(p, n);
    parameter real r = 1000 from (0:inf);
    inout p, n;
    electrical p, n;
    analog I(p, n) <+ V(p, n) / r;
endmodule

paramset ch10_begin_keywords_inside_a_paramset ch10_keywords_paramset_target;
  parameter real unused_item = 0;
`begin_keywords "1364-2005"
    .r = 2000;
endparamset
