// §10.4 (via IEEE Std 1364): a function-like macro's actual arguments are a
// parenthesis-delimited, comma-separated list, with nested (), [], {} and
// string literals opaque to the split. Opacity means MATCHED nesting — `[` is
// closed by `]` and only `]` — so `` `SQ(2.0] `` has no closing `)` at all and
// the argument list is unterminated: E0120.
//
// The discriminating shape: a scanner that keeps ONE depth counter for all
// three bracket kinds accepts this line silently (any of `)]}` decrements, so
// the `]` "closes" the `(`), and on crossed nestings it mis-slices arguments
// at commas that sit inside a bracket the writer never closed. VerA did
// exactly that. The expectation is the stable code, not a phase label: any
// later parse error on the leaked `]` would also fail the module, but only
// E0120 says the PREPROCESSOR refused the argument list.
//
//! lrm 10.4
//! reject-only E0120
`include "disciplines.vams"
`define SQ(x) ((x)*(x))
module ch10_mismatched_macro_argument_bracket(p, n);
  inout p, n; electrical p, n;
  analog I(p,n) <+ `SQ(2.0]*V(p,n);
endmodule
