// IEEE Std 1364 §19.9, carried over by §10.1 Table 10-1, gives `timescale a
// closed grammar and one semantic constraint on top of it:
//
//     `timescale <time_unit> / <time_precision>
//
// where each operand is 1, 10 or 100 glued to one of s, ms, us, ns, ps or fs
// (Table 19-1) — and "The time precision shall be at least as precise as the
// time unit."
//
// `1ps/1ns` is on the grid twice over and still not a timescale: it asks for a
// tick finer than the unit it measures, which has no reading. It is written
// this way round on purpose — a fixture whose operand is off Table 19-1
// (`2ns`, `1sec`) tests the LEXICAL half, which any tool that parses the
// directive at all gets right, while the ORDERING is a separate sentence that a
// tool can parse past without checking.
//
// §9.10 makes `$abstime` seconds regardless of this directive and 19 pins that,
// so nothing in the analog solve moves either way. What the operands DO reach
// is §9.15 Table 9-27, whose "timeUnit" and "timePrecision" rows are defined as
// "as specified in `timescale" (157 pins them), and the digital executor's
// tick. Neither can be supplied from a directive with no reading, which is why
// this is refused at the directive rather than at the far end of a compilation
// that may never ask.
//
//! lrm 10.1
//! reject-only E0142
`include "disciplines.vams"
`timescale 1ps/1ns
module ch10_timescale_precision_is_not_coarser_than_the_unit(p, n);
    inout p, n;
    electrical p, n;
    analog I(p, n) <+ V(p, n);
endmodule
