// §10.6 closes the set of version specifiers: "VAMS-2023" (this standard), plus
// '"1364-1995", "1364-2001", "1364-2005" and "VAMS-2.3" must also be supported'.
// Fixtures 16, 17, 25, 26 and 27 cover all five accepted spellings; nothing
// covered a specifier outside the enumeration.
//
// "1800-2017" is the specifier a front end is most likely to accept by accident
// — it is the IEEE Std 1800 SystemVerilog keyword list, valid for `begin_keywords
// in THAT standard and not in this one. Accepting it silently would leave the
// module parsed against a reserved-word set §10.6 never sanctions.
//
// §10.6 states the enumeration rather than an explicit "shall be an error"; the
// explicit form is IEEE Std 1364 §19.11, which chapter 10 extends rather than
// replaces.
//
//! lrm 10.6
//! reject E0135
`include "disciplines.vams"
`begin_keywords "1800-2017"
module ch10_begin_keywords_bad_specifier(p, n);
  inout p, n;
  electrical p, n;
  analog I(p, n) <+ V(p, n);
endmodule
`end_keywords
