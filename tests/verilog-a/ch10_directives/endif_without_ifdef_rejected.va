// IEEE 1364-2005 §19.4 Syntax 19-5 (taken whole by §10.1): `endif appears only
// as the last token of an ifdef_directive or ifndef_directive. The one below
// closes nothing.
//
//! lrm 10.1
//! inherited IEEE 1364-2005 19.4
//! reject-only E0108
`include "disciplines.vams"
`endif
module ch10_endif_without_ifdef(p, n);
  inout p, n; electrical p, n;
  analog I(p, n) <+ V(p, n);
endmodule
