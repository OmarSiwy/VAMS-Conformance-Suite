// IEEE 1364-2005 §19.3.1 (the `define rules §10.4 defers to): "If formal
// arguments are used, the list of formal argument names shall be enclosed in
// parentheses following the name of the macro." And: "The first newline not
// preceded by a backslash shall end the macro text."
//
// The list below opens and the line ends before any `)`. Without the
// backslash there is no continuation, so the list is never closed.
//
//! lrm 10.4
//! inherited IEEE 1364-2005 19.3.1
//! reject-only E0111
`include "disciplines.vams"
`define SQ(x
module ch10_define_formal_list_unterminated(p, n);
  inout p, n; electrical p, n;
  analog I(p, n) <+ V(p, n);
endmodule
