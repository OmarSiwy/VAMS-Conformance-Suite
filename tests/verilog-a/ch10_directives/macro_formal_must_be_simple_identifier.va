// Syntax 10-3 draws a distinction it would not have needed to draw:
//
//   text_macro_name           ::= text_macro_identifier [ ( list_of_formal_arguments ) ]
//   list_of_formal_arguments  ::= formal_argument_identifier { , formal_argument_identifier }
//   formal_argument_identifier ::= simple_identifier
//   text_macro_identifier     ::= identifier
//
// Two different nonterminals for two positions in the same production. Annex
// A.9.3 has identifier ::= simple_identifier | escaped_identifier, so the macro
// NAME may be escaped and a FORMAL may not. This file pins the restrictive
// half; 47 pins the permissive half it is contrasted with, and 05 covers the
// ordinary simple-identifier formal that both agree is legal.
//
// The rule has a mechanical reason behind it, which is why it is worth pinning
// rather than a drafting accident: an escaped identifier runs to the next white
// space (§2.7.1), so a formal written `\esc-x` would swallow the comma or the
// closing parenthesis that ends the argument list, and the list would have no
// terminator the preprocessor could find.
//
// E0110 is VerA's "malformed formal argument list for `define", which is this
// rule under a different name — the code is the stable form and the message
// wording is free to change.
//
//! lrm 10.4
//! reject-only E0110
`include "disciplines.vams"
`define SQUARE(\esc-x ) ((\esc-x )*(\esc-x ))
module ch10_macro_formal_must_be_simple_identifier(p, n);
  inout p, n; electrical p, n;
  analog I(p, n) <+ `SQUARE(V(p, n));
endmodule
