// §10.6 makes the pairing normative: the `begin_keywords directive "affects all
// source code that follows the directive, even across source code file
// boundaries, until the matching `end_keywords directive is encountered."
//
// A stray `end_keywords has no matching `begin_keywords and therefore no set to
// restore. A tool that swallows it silently has no way to be right about what is
// reserved afterwards — it either pops a set it never pushed or does nothing,
// and neither is the "matching" behaviour the clause describes.
//
// Nothing else in the file is unusual, so the only thing under test is the
// unpaired directive; the module below is the same one-resistor body as 16.
//
// WHAT THIS FIXTURE ASSUMES, since §10.6 nowhere writes "shall be an error".
// The explicit form is IEEE Std 1364 §19.11, which §10.6 extends rather than
// replaces — its first sentence is "Verilog-AMS HDL extends the
// `begin_keywords and `end_keywords compiler directives from IEEE Std 1364
// Verilog". The cross-file sentence quoted above also cuts the other way for a
// tool handed SEVERAL files in one invocation: there an `end_keywords in file
// N may legitimately match a `begin_keywords in file N-1, and refusing it
// would be wrong. This suite compiles one file per invocation, so in the
// compilation unit as the runner presents it there is nothing for the
// directive below to match. That is also why 31 — whose only defect appears
// across a file boundary, and which §10.6 therefore describes rather than
// forbids — is a run fixture and this one is not.
//
//! lrm 10.6
//! reject-only E0136
`include "disciplines.vams"
`end_keywords
module ch10_end_keywords_unmatched(p, n);
  inout p, n;
  electrical p, n;
  analog I(p, n) <+ V(p, n);
endmodule
