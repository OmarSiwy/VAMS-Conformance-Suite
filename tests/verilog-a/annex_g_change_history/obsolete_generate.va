// Annex G Table G.1 ("Generate statement | generate | N/A | Obsolete") and
// G.2.3 Figure G-1: the v1.0 form is `generate index (start, end [, incr])
// statement`, an ANALOG statement unrolled at elaboration, and it is gone.
// It is not the modern §6.6 generate construct (`genvar`, `generate ... endgenerate`
// at module level), which is current language and is owned by
// ch06_hierarchy/generate_loop.va. The bare word `generate` in a diagnostic proves
// nothing on its own. The code below is the obsolete form: inside an analog
// block, with the parenthesised index bounds of Figure G-1.
//
// E0209 pins WHERE it dies: `generate` is not an analog statement keyword, so
// the parser is still looking for an expression when it meets it.
//
//! lrm G.1
//! lrm G.2.3
//! lrm A.6.4
//! lrm A.6.4:1000
//! reject-only E0209
//! reject generate
//! neighbour ../ch06_hierarchy/generate_loop.va
`include "disciplines.vams"
module annex_g_obsolete_generate(p, n);
  inout p, n; electrical p, n;
  analog begin
    generate i (0, 3) I(p,n) <+ V(p,n);
  end
endmodule
