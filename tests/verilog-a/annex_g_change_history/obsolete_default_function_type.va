// Annex G.2.4: "The `default_function_type_analog directive is no longer
// supported. this compiler directive allowed user-defined functions to be
// treated as analog functions in Verilog-A if they did not have the key word
// analog as part of the definition." It is not a compiler directive of this
// language, so §10 leaves the name undefined and it is diagnosed as an unknown
// macro, E0115. Its Table G.1 twin is default_nodetype_rejected.va.
//
// The portable claim is the CITE -- another compiler will pick another code --
// but the code is what pins which rule fired here, where the bare phase label
// `ParseError` would stay green on a typo anywhere in the file.
//
//! lrm G.2.4
//! reject-only E0115
//! reject default_function_type_analog
`include "disciplines.vams"
`default_function_type_analog real
module annex_g_obsolete_default_function_type(p, n);
  inout p, n; electrical p, n;
  analog I(p,n) <+ V(p,n);
endmodule
