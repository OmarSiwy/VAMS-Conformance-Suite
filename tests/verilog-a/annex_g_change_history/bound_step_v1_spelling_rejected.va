// Annex G Table G.1 ("Timestep control (maximum stepsize) | bound_step(
// const_expression) | $bound_step(expr) | syntax"). The unprefixed v1.0
// spelling is retired; §9.17.2 gives only `$bound_step ( expression ) ;`. The
// current spelling is covered by ch09_system_tasks/bound_step.va.
//
// READ THE CODE CAREFULLY. E0214 "expected '<+' or '='" is a statement-SHAPE
// error, not a name lookup: without the `$` the parser reads `bound_step(1n)`
// as the left-hand side of a contribution or an assignment and then meets `;`.
// The rejection is right, the reason is incidental -- if VerA ever grows name
// resolution at this position the code will change while the cite still holds,
// so it is the cite that is portable here.
//
//! lrm G.1
//! lrm 9.17.2
//! reject-only E0214
//! neighbour ../ch09_system_tasks/bound_step.va
`include "disciplines.vams"
module annex_g_bound_step_v1_spelling(p, n);
  inout p, n; electrical p, n;
  analog begin
    bound_step(1n);
    I(p,n) <+ V(p,n);
  end
endmodule
