// Annex G Table G.4 item 2 (v2.2 -> v2.3): "Add apostrophe before opening { in
// list of values (to distinguish a list of values from the concatenation
// operator)". The change text is its own justification: without the leading
// apostrophe `{2.1, 4.5}` is a concatenation, and a front end that accepts it as
// an array initialiser cannot tell the two constructs apart. Table G.1's "Array
// setting" row shows the same expression evolving from v1.0's
// `{2.1 = (1), 4.5 = (2)}` to a plain list, which the apostrophe was then added
// in front of.
//
// DO NOT COPY THE ANNEX'S CLAUSE NUMBER. Table G.4's clause column reads "3.4.2"
// in v2.3 numbering; in the shipped document §3.4.2 is "Value range
// specification" (`from`/`exclude`) and says nothing about `'{`. The live
// clauses are:
//
//   §3.4 -- "For parameters defined as arrays, the initializer shall be a
//            constant_assignment_pattern expression ... using an assignment
//            pattern (see 4.2.14), i.e. within '{ and } delimiters." (shall)
//   §3.4.4 -- the example: parameter real poles[0:3] = '{ 1.0, 3.198, ... };
//   §4.2.14 -- "The assignment pattern '{ }, is the way to specify lists of
//            expressions of particular type ... particularly array assignments",
//            and §4.2.13 separates it from the brace concatenation operator.
//
// The legal '{...} form is covered by ch03_data_types/parameter_array.va and
// ch04_expressions/assignment_pattern.va.
//
// Either diagnosis is conforming -- a missing apostrophe, or an unsized
// concatenation in a real-valued initialiser. VerA's is the first: E0349
// "array parameter initialiser is not an assignment pattern", which is the
// §3.4 sentence quoted above, and it replaces the phase label pinned before
// the code existed. The parameter is still deliberately NOT referenced in the
// analog block, so the declaration is the whole test.
//
//! lrm G.1
//! lrm 3.4
//! lrm 3.4:2
//! lrm 4.2.14
//! lrm 4.2.14:1000
//! reject-only E0349
//! neighbour ../ch03_data_types/parameter_array.va
//! neighbour ../ch04_expressions/assignment_pattern.va
`include "disciplines.vams"
module annex_g_brace_array(p, n);
  inout p, n; electrical p, n;
  parameter real coeffs[0:1] = {2.1, 4.5};
  analog I(p,n) <+ V(p,n);
endmodule
