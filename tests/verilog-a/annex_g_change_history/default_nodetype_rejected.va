// Annex G Table G.1, Obsolete rows: "`default_nodetype | `default_nodetype |
// `default_discipline | Obsolete". The v1.0 directive that gave implicit nodes
// a discipline was renamed, and §10.2 knows only `default_discipline; the old
// name is not a compiler directive of this language and shall be diagnosed.
//
// It is one keystroke away from the legal IEEE 1364 `default_nettype, which is
// why it is worth a fixture of its own: a slip there must not be silently
// ignored. Its G.2.4 twin is obsolete_default_function_type.va.
//
//! lrm G.1
//! lrm 10.2
//! reject-only E0115
//! reject default_nodetype
`include "disciplines.vams"
`default_nodetype electrical
module annex_g_default_nodetype(p, n);
  inout p, n; electrical p, n;
  analog I(p,n) <+ V(p,n);
endmodule
