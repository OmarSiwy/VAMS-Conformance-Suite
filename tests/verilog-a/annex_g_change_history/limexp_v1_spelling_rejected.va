// Annex G Table G.1, "Limiting exponential function": the OVI Verilog-A v1.0
// spelling `$limexp( expression )` was replaced in v2.0 by `limexp( expression
// )`, a syntax change. The retired form is not an alias -- a `$` name is a
// system function (§9), and §4.5.13 defines the analog operator under the bare
// name only. Accepting both is the backward-compatibility leak Table G.1
// exists to close.
//
// The current spelling is covered by ch04_expressions/limexp.va.
//
// The LRM's position is that the NAME does not exist: `$limexp` is absent from
// Table 9-11 and from A.8.2, so the conforming diagnosis is an unknown function,
// not "unsupported" (E0801, which is RETIRED). E0808 ("retired Verilog-A v1.0
// spelling") is that diagnosis: it is emitted at the call in lowering, says the
// name was replaced, and names `limexp`. It replaces the phase label this file
// pinned while codegen silently aliased `$limexp` to `limexp`.
//
//! lrm G.1
//! lrm 4.5.13
//! reject-only E0808
//! neighbour ../ch04_expressions/limexp.va
`include "disciplines.vams"
module annex_g_limexp_v1(p, n);
  inout p, n; electrical p, n;
  analog I(p,n) <+ $limexp(V(p,n));
endmodule
