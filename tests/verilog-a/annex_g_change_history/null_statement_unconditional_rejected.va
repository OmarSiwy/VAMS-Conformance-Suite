// Annex G G.2.2 NULL: "This statement is no longer supported. Certain
// functions such as case, conditionals and the event statement do allow null
// statements as defined by the syntax." Table G.1's last row says the same:
// the null went from `;` to "limited to case, conditional, and event
// statements".
//
// The syntax is where that is normative. A.6.4 lists every `analog_statement`
// alternative and none is `;`; the null exists only in
// `analog_statement_or_null ::= analog_statement | { attribute_instance } ;`,
// which is reached from a conditional arm, a case item and an event statement.
// `analog_seq_block` (A.6.3) takes `{ analog_statement }`, so a free-standing
// `;` inside `analog begin ... end` is underivable.
//
// The legal, conditional null is null_statement_scope.va.
//
//! lrm G.2.2
//! lrm A.6.4
//! lrm A.6.4:1000
//! reject-only E0219
//! neighbour null_statement_scope.va
`include "disciplines.vams"
module annex_g_null_unconditional(p, n);
  inout p, n; electrical p, n;
  analog begin
    ;
    I(p,n) <+ V(p,n);
  end
endmodule
