// Annex G Table G.2 item 13: "@(final_step) without arguments should not have
// parenthesis" (5.10.2, Table 5-1). A.6.5 makes that mechanical --
//   analog_event_expression ::= ... | final_step [ ( " analysis_identifier "
//                                    { , " analysis_identifier " } ) ]
// -- the analysis list inside the parentheses is NON-EMPTY, and the whole
// parenthesised group is what is optional. So `final_step()` is not derivable:
// either omit the parentheses or name at least one analysis.
//
// Both legal forms are already covered: ch05_analog_behavior/final_step.va uses
// bare `@(final_step)` and ch05_analog_behavior/initial_final_analysis_lists.va
// uses the analysis-list form. Only the error was open.
//
// No numeric want here on purpose: this fixture is about a grammar production
// having no derivation, and the arm's body is never meant to be reached.
//
//! lrm G.1
//! lrm 5.10.2
//! lrm A.6.5
//! lrm 5.10.2:1000
//! lrm A.6.5:1000
//! reject-only E0220
//! neighbour ../ch05_analog_behavior/final_step.va
//! neighbour ../ch05_analog_behavior/initial_final_analysis_lists.va
`include "disciplines.vams"
module annex_g_final_step_empty_parens(p, n);
  inout p, n; electrical p, n;
  real x;
  analog begin
    x = 1.0;
    @(final_step()) x = 0.0;
    I(p,n) <+ V(p,n) + 0.0 * x;
  end
endmodule
