// LRM 5.9: the analog looping statements are repeat, while and for --
// `forever` is not one of them. Annex G G.2.1 Forever: "This statement is no
// longer supported." It remains a reserved word (Annex B.1), so it cannot be
// reached as an identifier either.
//
// E0256 is raised AT the keyword, and the loop is then parsed in full, so the
// rest of the module reports nothing.
//! lrm G.2.1
//! lrm 5.9
//! reject-only E0256
//! reject forever
`include "disciplines.vams"
module annex_g_obsolete_forever(p, n);
  inout p, n; electrical p, n;
  analog forever begin
    I(p,n) <+ V(p,n);
  end
endmodule
