// Annex G Table G.1 ("Discontinuity function | discontinuity(x) |
// $discontinuity(x) | syntax"). The unprefixed v1.0 spelling is retired;
// §9.17.1 gives only `$discontinuity [ ( constant_expression ) ] ;`. The
// current spelling is covered by ch09_system_tasks/discontinuity.va. Twin of
// bound_step_v1_spelling_rejected.va.
//
// Same caveat as 17: E0214 "expected '<+' or '='" is a statement-SHAPE error,
// not a name lookup -- without the `$` the parser reads `discontinuity(0)` as
// the left-hand side of a contribution and then meets `;`. The rejection is
// right and the reason is incidental; the cite is the portable half.
//
//! lrm G.1
//! lrm 9.17.1
//! reject-only E0214
//! neighbour ../ch09_system_tasks/discontinuity.va
`include "disciplines.vams"
module annex_g_discontinuity_v1_spelling(p, n);
  inout p, n; electrical p, n;
  analog begin
    discontinuity(0);
    I(p,n) <+ V(p,n);
  end
endmodule
