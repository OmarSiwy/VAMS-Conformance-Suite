// Annex G Table G.2 item 2: "Not to use 'max' and use 'maxval' instead since
// max is a keyword" (clauses 3.6.1.1, 3.6.2.6). The pair matters: `maxval` is
// the nature attribute, `max` is a reserved word -- Annex B.1 lists it -- so it
// cannot appear where nature_attribute wants an attribute_identifier, whatever
// a v2.0 nature declaration used to spell.
//
// The corrected spelling is covered by ch03_data_types/nature_declarations.va;
// only the retired one was untested. E0208 pins that the parser is asking for an
// identifier at that position and got a keyword.
//
//! lrm G.1
//! lrm 3.6.1.1
//! lrm 3.6.2.6
//! reject-only E0208
//! reject max
//! neighbour ../ch03_data_types/nature_declarations.va
`include "disciplines.vams"
nature n_test;
  units = "V";
  access = V;
  abstol = 1e-6;
  max = 10.0;
endnature
module annex_g_max_nature_attribute(p, n);
  inout p, n; electrical p, n;
  analog I(p,n) <+ V(p,n);
endmodule
