// Annex G Table G.1 carries $realtime twice: "Analog time | $realtime |
// $abstime | new", and a later row "$realtime :timescale = 1 sec | $realtime
// :timescale = `timescale def=1n, see $abstime | definition". Read alone, the
// second row invites a fixture asserting that $realtime in an analog block reads
// the time in timescale units -- 1000 at t = 1 us with a 1 ns timescale. THAT
// FIXTURE WOULD BE WRONG, and this one replaces it.
//
// Annex G is a history, and G.1's own preamble says the current document
// supersedes the syntax and semantics of previous revisions. What the current
// document says about $realtime in the analog context is that there is no such
// thing:
//
//   Table 9-7 "Simulation Time System Functions" -- $realtime: supported in
//     digital context Yes, supported in ANALOG context NO. ($abstime is the
//     only row in that table with Yes in both columns.)
//   §9.10 -- "NOTE—In previous versions of the Verilog-AMS LRM, $realtime was
//     supported in the analog context and it had an additional argument. This
//     version of the LRM deprecates using $realtime in the analog context."
//
// So the portable requirement is not a value, it is the refusal: an analog block
// may not read $realtime, and a compiler that answers with a number -- 1000 or
// 1e-6 -- has answered a question the LRM withdrew. Writing 1000.0 as a `want`
// would demand that every conforming compiler keep the deprecated v2.0 reading
// forever, and would fail one that diagnoses the use, which is exactly what
// "deprecates" invites.
//
// abstime_replaced_realtime.va owns the positive half of the same Annex G
// row: $abstime is the analog spelling and it is in SECONDS whatever `timescale
// says. It runs green, and stays out of this file so that this one is about the
// refusal and nothing else.
//
// E0806 ("system task is not supported in the analog context") is what VerA
// emits now: Table 9-7's "No" in the analog column, which is the rule this file
// is about. It replaces the phase label pinned while VerA emitted nothing here.
// The module's only defect is the $realtime read.
//
//! lrm G.1
//! lrm 9.10
//! lrm 9.2
//! lrm 9.2:1000
//! reject-only E0806
//! neighbour abstime_replaced_realtime.va
`include "disciplines.vams"
`timescale 1ns/1ns
module annex_g_realtime_analog_context(p, n);
  inout p, n; electrical p, n;
  analog begin
    // $realtime is a plain addend, not a factor on a zero, so no amount of
    // constant folding can make the read disappear before it is checked.
    I(p,n) <+ $realtime + 0.0 * V(p,n);
  end
endmodule
