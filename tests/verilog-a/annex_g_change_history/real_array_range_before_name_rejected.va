// Annex G Table G.2 (v2.0 to v2.1, under G.1) item 12: "Array declaration wrongly specified before the
// variable identifier. For variables, array specification is written after
// the name of the variable." (clause column: 3.2). The live rule is A.2.1.3:
// `real_declaration ::= real list_of_real_identifiers` and
// `real_type ::= real_identifier { dimension } [ = ... ]`, so the dimension
// follows the identifier and nothing may sit between `real` and the name.
// `real [0:3] x;` therefore derives from nothing, and the parser stops at the
// `[` where §2.8's identifier is required (E0208).
//
// Legal neighbour: real_array_range_after_name.va, `real x[0:3];`, which
// stores and reads back all four elements.
//
//! lrm G.1
//! lrm 3.2
//! lrm A.2.1.3
//! reject-only E0208
//! reject found `[`
//! neighbour real_array_range_after_name.va
`include "disciplines.vams"
module annex_g_real_array_range_before_name(p);
  inout p; electrical p;
  real [0:3] x;
  analog I(p) <+ V(p);
endmodule
