// Annex G Table G.1 ("Continuous waveform delay | delay() | absdelay() |
// syntax"), restated as Table G.2 item 11 ("absdelay instead of delay"). The
// v1.0 name was retired: §4.5.7 defines the operator as `absdelay`, `delay` is
// absent from the Annex B.1 keyword list and from A.8.2's
// analog_filter_function_call, so it names nothing.
//
// A compiler with no such name reports an undefined function -- that IS the
// conforming outcome, so this is a regression guard against a front end that
// quietly keeps both spellings, not a bug report. The current spelling is
// covered by the absdelay fixtures.
//
// CITE DISCREPANCY, recorded so a coverage diff against Annex G does not read as
// a miss: Table G.2's clause column for item 11 says 4.5.14, the absolute-delay
// clause under v2.1 numbering. In the shipped document §4.5.7 is "Absolute delay
// operator" and §4.5.14 is "Constant versus dynamic arguments", so 4.5.7 is the
// cite and the annex's number is the stale one.
//
//! lrm G.1
//! lrm 4.5.7
//! reject-only E0512
//! reject delay
`include "disciplines.vams"
module annex_g_delay_v1_spelling(p, n);
  inout p, n; electrical p, n;
  analog I(p,n) <+ delay(V(p,n), 1n);
endmodule
