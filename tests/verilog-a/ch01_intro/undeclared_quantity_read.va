// §1.3.5: "port and net declarations only require types for those values which
// are actually used in the description ... In summary, only those signals types
// declared on the ports are accessible in the body of the model." Read the
// other way round, a type that was NOT declared is not accessible — and §1.3.4
// says why in so many words: for a node bound only to potential-nature
// disciplines, "flow for such a node is not defined".
//
// This is the READ side, and it is a separate claim from the write side.
// signal_flow_illegal_quantity.va and potential_contribution_to_flow_only.va
// pin the two halves of the contribution rule; a compiler can perfectly well
// reject a contribution to an undefined quantity (the left of a `<+` is a
// distinguished position it already inspects) while letting the same quantity be
// read in an expression. Here `V(vonly) <+ 1.0` is LEGAL — `voltage` is Annex D's
// potential-only discipline and potential is exactly what it declares — and the
// sole defect is `I(vonly)` appearing as an operand.
//
// `vonly` is an internal net rather than a port on purpose: a single-nature
// discipline on a port drags in the §1.3.4.1/§1.3.4.2 direction rules, which
// 15-18 already pin separately. The rule under test here is about the declared
// nature, not about the port direction.
//
// Pin the rule-specific diagnostic: binds no flow nature.
// An unrelated parser or code-generation failure cannot satisfy this fixture.
// Earlier DiagnosticsReported matching and obsolete unallocated-code arguments
// are superseded by the Chapter 1 source review (2026-09-23).
//
// §4.4 is cited alongside §1.3.5 because §1.3.5's sentence is about PORTS, and
// `vonly` is deliberately an internal net; §4.4's access-function rules are what
// make `I(vonly)` an error on a net.
//
//! lrm 1.3.5
//! lrm 1.3.4
//! lrm 4.4
//! lrm 1.3.5:1000
//! lrm 4.4:5
//! reject-only binds no flow nature
//! neighbour mixed_conservative_signal_flow.va
`include "disciplines.vams"
module ch01_undeclared_quantity_read(p, n);
    inout p, n;
    electrical p, n;
    voltage vonly;
    real x;

    analog begin
        x = I(vonly);
        V(vonly) <+ 1.0;
        I(p, n) <+ V(p, n) * 1.0e-3 + x;
    end
endmodule
