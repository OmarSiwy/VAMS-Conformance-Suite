// §1.3.4 "If a node is bound only to disciplines which have potential nature
// only, current contributions to that node are not legal. Flow for such a node
// is not defined." `vonly` is Annex D's `voltage` — a potential-only signal-flow
// discipline — so `I(vonly)` names a quantity the node does not have.
//
// The conservative contribution on (p, n) is there only so the module is a
// well-formed device; the sole defect is the flow contribution to `vonly`.
//
// Pin the rule-specific diagnostic: binds no flow nature.
// An unrelated parser or code-generation failure cannot satisfy this fixture.
// Earlier DiagnosticsReported matching and obsolete unallocated-code arguments
// are superseded by the Chapter 1 source review (2026-09-23).
//
//! lrm 1.3.4
//! lrm 1.3.4:1001
//! reject-only binds no flow nature
//! neighbour signal_flow_single_nature_contributions.va
`include "disciplines.vams"
module ch01_signal_flow_illegal_quantity(p, n);
    inout p, n;
    electrical p, n;
    voltage vonly;

    analog begin
        I(vonly) <+ 1.0e-3;
        I(p, n) <+ V(p, n) * 1.0e-3;
    end
endmodule
