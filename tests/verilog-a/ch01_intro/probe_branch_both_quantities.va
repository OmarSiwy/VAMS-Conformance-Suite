// §5.4.2.1, printed 100 / physical PDF page 113: a branch with no
// contribution is a probe; reading both its potential and flow is illegal.
// Here prb is never contributed to, and the output branch (o,r) is disjoint.
// Therefore V(prb) + I(prb) must be rejected. A source branch would instead
// permit both reads (§5.4.2.2), so adding a contribution changes the premise.
//
// The former §1.3.1 quotation and primary tag were incorrect: that clause
// refers to §5.4.2 but does not contain the prohibition. The evidence obligation
// remains at INTRO-PROBE-001 in docs/conformance-introduction-review.md at 8b1514d4 / §5.4.2.1.
// Pin the rule-specific diagnostic, not the former DiagnosticsReported catchall.
//
//! lrm 5.4.2.1
//! lrm 5.4.2.1:1
//! reject-only both quantities of a probe branch are read
//! reject E0423
`include "disciplines.vams"
module ch01_probe_branch_both_quantities(p, n, o, r);
    inout p, n, o, r;
    electrical p, n, o, r;
    branch (p, n) prb;

    analog I(o, r) <+ V(prb) + I(prb);
endmodule
