// §1.3.4.1 "Nets of potential signal flow disciplines in modules may only be
// bound to `input` or `output` ports of the module, not to `inout` ports."
//
// `voltage` is Annex D's potential-only signal-flow discipline, so binding it to
// an `inout` port is the violation on its own — no analog statement is needed to
// commit it. The contribution below is present only so the module is a device.
//
// The code is E0360, which now exists. It WAS `//! reject E0337` — a code
// class 3 had not allocated — and then `DiagnosticsReported`, the phase label,
// which is what a fixture writes while the rule has no number yet: a code VerA
// cannot emit never matches, so pinning one reserves nothing and only hides the
// gap. Now that the rule is implemented the code is the stronger expectation, and
// it pins WHICH rule fired rather than that something did.
//
//! lrm 1.3.4.1
//! lrm 1.3.4.1:2
//! reject-only E0360
//! neighbour potential_signal_flow.va
`include "disciplines.vams"
module ch01_sf_potential_on_inout(p);
    inout p;
    voltage p;

    analog V(p) <+ 1.0;
endmodule
