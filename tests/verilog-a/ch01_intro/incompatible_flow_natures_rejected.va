// §1.3.3: "The disciplines associate potential and flow natures for
// conservative systems ... The natures are a collection of attributes ...
// which describes the units (meter, gram, newton, etc.), absolute tolerance for
// convergence, and the names of potential and flow access functions. ... The
// compatibility rules help enforce the legal operations between nets of
// different disciplines."
//
// So a discipline is its PAIR of natures, and whether an operation over nets of
// two disciplines is legal is decided by those natures. The rules themselves
// are §3.11/§3.11.1's: "if an access function has two nets as arguments, they
// must be compatible", and the Flow Incompatibility Rule makes "disciplines
// with incompatible flow natures ... incompatible" even when the potential
// natures are the same.
//
// `ch1_volt_force` binds annex D's `Voltage` as its potential — the same
// nature `electrical` binds, so `V` is a legal access for both nets and the
// Self Rule makes the potentials compatible — and annex D's `Force` (units "N",
// access `F`) as its flow. `Current` (units "A") and `Force` share no base
// nature and no units value, so no §3.11.1 nature rule makes them compatible,
// and `V(elec, mech)` is an access over two incompatible nets. That is the one
// defect in the file: with `flow Current;` instead, the disciplines bind the
// same two natures and the same file compiles (checked by hand when this
// fixture was written). ch03_data_types/incompatible_nets_access.va is the
// potential-half twin, E0355 on the Potential Incompatibility Rule.
//
//! lrm 1.3.3
//! lrm 3.11
//! lrm 3.11:1
//! reject-only E0355
`include "disciplines.vams"
discipline ch1_volt_force;
    potential Voltage;
    flow Force;
enddiscipline

module ch01_incompatible_flow_natures(p, n);
    inout p, n;
    electrical p, n;
    electrical elec;
    ch1_volt_force mech;

    analog begin
        I(p, n) <+ V(elec, mech) * V(p, n);
    end
endmodule
