// §1.3.4.2, second sentence of the port restriction: "Flow contributions may not
// be made to input ports in this case."
//
// The mirror of sf_potential_contribution_to_input.va. The DECLARATION is
// legal — `current` on an `input` port is exactly what currmir writes — and it is
// the CONTRIBUTION `I(inp) <+ ...` that the clause forbids. The contribution to
// `outp` is legal and is there to show the rule is about direction.
//
// Pin the rule-specific diagnostic: contribution to an `input` signal-flow port.
// An unrelated parser or code-generation failure cannot satisfy this fixture.
// Earlier DiagnosticsReported matching and obsolete unallocated-code arguments
// are superseded by the Chapter 1 source review (2026-09-23).
//
//! lrm 1.3.4.2
//! lrm 1.3.4.2:3
//! reject-only contribution to an `input` signal-flow port
//! reject E0425
//! neighbour flow_signal_flow.va
`include "disciplines.vams"
module ch01_sf_flow_contribution_to_input(inp, outp);
    input inp;
    output outp;
    current inp, outp;

    analog begin
        I(inp) <+ 1.0e-3;
        I(outp) <+ 2.0e-3;
    end
endmodule
