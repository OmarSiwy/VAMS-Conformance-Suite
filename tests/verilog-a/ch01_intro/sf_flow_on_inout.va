// §1.3.4.2 "Nets of flow signal-flow disciplines in modules may only be bound to
// input or output ports of the module, not to inout ports."
//
// The mirror of sf_potential_on_inout.va. `current` is Annex D's flow-only
// signal-flow discipline, so binding it to an `inout` port is the violation on
// its own; the contribution below is present only so the module is a device.
//
// Both halves of the restriction are one rule and share the code — see the note
// in sf_potential_on_inout.va for what E0360 replaced. Kept in its own file so
// a run says which half fired: a compiler can plausibly check the potential-only
// binding and miss the flow-only one.
//
//! lrm 1.3.4.2
//! lrm 1.3.4.2:2
//! reject-only E0360
//! neighbour flow_signal_flow.va
`include "disciplines.vams"
module ch01_sf_flow_on_inout(p);
    inout p;
    current p;

    analog I(p) <+ 1.0e-3;
endmodule
