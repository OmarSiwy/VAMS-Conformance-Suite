// §1.3.4.1, second sentence of the port restriction: "In that case, potential
// contributions may not be made to `input` ports."
//
// Distinct from sf_potential_on_inout.va: here the DECLARATION is legal —
// `voltage` on an `input` port is exactly what shiftPlus5 writes — and it is the
// CONTRIBUTION `V(inp) <+ ...` that the clause forbids. The contribution to
// `outp` is legal and is there to show the rule is about direction, not about
// the discipline.
//
// Pin the rule-specific diagnostic: contribution to an `input` signal-flow port.
// An unrelated parser or code-generation failure cannot satisfy this fixture.
// Earlier DiagnosticsReported matching and obsolete unallocated-code arguments
// are superseded by the Chapter 1 source review (2026-09-23).
//
//! lrm 1.3.4.1
//! lrm 1.3.4.1:3
//! reject-only contribution to an `input` signal-flow port
//! reject E0425
//! neighbour potential_signal_flow.va
`include "disciplines.vams"
module ch01_sf_potential_contribution_to_input(inp, outp);
    input inp;
    output outp;
    voltage inp, outp;

    analog begin
        V(inp) <+ 1.0;
        V(outp) <+ 2.0;
    end
endmodule
